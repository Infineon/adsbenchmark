// Disclaimer:
// THIS FILE IS PROVIDED AS IS AND WITH:
// (A) NO WARRANTY OF ANY KIND, express, implied or statutory, including any implied warranties of merchantability, fitness for a particular purpose and noninfringement, which  Infineon disclaims to the maximum extent permitted by applicable law; and
// (B) NO INDEMNIFICATION FOR INFRINGEMENT OF INTELLECTUAL PROPERTY RIGHTS.
// (C) LIMITATION OF LIABILITY: IN NO EVENT SHALL INFINEON BE LIABLE FOR ANY DIRECT, INDIRECT, SPECIAL, INCIDENTAL, OR CONSEQUENTIAL DAMAGES (INCLUDING LOST PROFITS OR SAVINGS) WHATSOEVER, WHETHER BASED ON CONTRACT, TORT OR ANY OTHER LEGAL THEORY, EVEN IF ADVISED OF THE POSSIBILITY OF SUCH DAMAGES.
// © 2020 Infineon Technologies AG. All rights reserved.

// Note:
// The CMOS transistor models used, were freely available models downloaded from: http://ptm.asu.edu.
// The bipolar transistor models are from: The Development of Bipolar Log-Domain Filters in a Standard CMOS Process, G. D. Duerden, G. W. Roberts, M. J. Deen, 2001

// Release:
// 	version 1.1

/*
* HSTX_PRBS
* ---------
* Generate the prbs for the HSTX channels
*/

/*
* Parameters
*/
parameter integer prbs_offset = 0;

integer internal_state [ 8:0] = {1,1,1,1,1,1,1,1,1};
integer tmp;

analog begin
    /*
    * We need different seeds for different lanes
    */
	@(initial_step) begin
        for (j = 0; j<9; j=j+1) begin
            internal_state[j] = 1;
        end
        if (prbs_offset==1) begin
            internal_state[0] = 0;
        end
        if (prbs_offset==2) begin
            internal_state[1] = 0;
        end
        if (prbs_offset==3) begin
            internal_state[0] = 0;
            internal_state[1] = 0;
        end
        if (prbs_offset==4) begin
             internal_state[2] = 0;
        end
    end

    /*
    * Update PRBS
    */
	@(cross(V(clk_i)-vhigh/2, -1)) begin
        if(mode==MODE_HSTX_PRBS) begin

            for (j = 0; j<16; j=j+1) begin

                tmp = (internal_state[4]^internal_state[8]);
                // Shift one in direction of MSB
                for (i = 7; i>=0; i=i-1) begin
                    internal_state[i+1] = internal_state[i];
                end
                internal_state[0] = tmp;
                hstx_data[j] = internal_state[0];
            end
            $strobe("Lane %d) Sending: %d%d%d%d.%d%d%d%d.%d%d%d%d.%d%d%d%d",
                    prbs_offset,
                    hstx_data[15],
                    hstx_data[14],
                    hstx_data[13],
                    hstx_data[12],
                    hstx_data[11],
                    hstx_data[10],
                    hstx_data[9],
                    hstx_data[8],
                    hstx_data[7],
                    hstx_data[6],
                    hstx_data[5],
                    hstx_data[4],
                    hstx_data[3],
                    hstx_data[2],
                    hstx_data[1],
                    hstx_data[0]
                    );
        end
    end
end

/*
* Reset this state when entered
*/
analog begin
	@(cross(V(reset_i) - vhigh/2, +1)) begin
        if(mode==MODE_HSTX_PRBS) begin

            for (j = 0; j<9; j=j+1) begin
                internal_state[j] = 1;
            end
            if (prbs_offset==1) begin
                internal_state[0] = 0;
            end
            if (prbs_offset==2) begin
                internal_state[1] = 0;
            end
            if (prbs_offset==3) begin
                internal_state[0] = 0;
                internal_state[1] = 0;
            end
            if (prbs_offset==4) begin
                internal_state[2] = 0;
            end
            // Output already first valid byte
            for (j = 0; j<16; j=j+1) begin

                tmp = !(internal_state[4]^internal_state[8]);
                // Shift one in direction of MSB
                for (i = 7; i>=0; i=i-1) begin
                    internal_state[i+1] = internal_state[i];
                end
                internal_state[0] = tmp;
                hstx_data[j] = internal_state[0];
            end
        end
    end
end

/*
* Main entry point
*/
analog begin
    if(mode == MODE_HSTX_PRBS) begin

        dft_deser_en            = 1; // Enable the de-serializer in the loop-back test path

        dft_hstx_higher_path_en = 1; // Disable these paths for impedance measurement?
        dft_hstx_lower_path_en  = 1;

        dft_ser_test_in_en      = 0; // Enable the inputs x_dft_ser_test_(p/n)_i to do HSTX DC tests

        dft_ser_test_n          = 0; // Forces a state on OCD
        dft_ser_test_p          = 0; // Forces a state on OCD

        hs_ser_en               = 1; // Enable serializer

        lptx_dn                 = 0;
        lptx_dp                 = 0;

        hstx_en_lptx_dis        = 1; // 1 = HSTX on, LPTX off 0 = HSTX off, LPTX on
        hstx_pwrdn              = 0; // 1 = HSTX disable (we want to keep it at least alive)
        lptx_en                 = 1; // 1 = LPTX enable
    end

end
