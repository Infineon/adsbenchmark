// Disclaimer:
// THIS FILE IS PROVIDED AS IS AND WITH:
// (A) NO WARRANTY OF ANY KIND, express, implied or statutory, including any implied warranties of merchantability, fitness for a particular purpose and noninfringement, which  Infineon disclaims to the maximum extent permitted by applicable law; and
// (B) NO INDEMNIFICATION FOR INFRINGEMENT OF INTELLECTUAL PROPERTY RIGHTS.
// (C) LIMITATION OF LIABILITY: IN NO EVENT SHALL INFINEON BE LIABLE FOR ANY DIRECT, INDIRECT, SPECIAL, INCIDENTAL, OR CONSEQUENTIAL DAMAGES (INCLUDING LOST PROFITS OR SAVINGS) WHATSOEVER, WHETHER BASED ON CONTRACT, TORT OR ANY OTHER LEGAL THEORY, EVEN IF ADVISED OF THE POSSIBILITY OF SUCH DAMAGES.
// © 2020 Infineon Technologies AG. All rights reserved.

// Note:
// The CMOS transistor models used, were freely available models downloaded from: http://ptm.asu.edu.
// The bipolar transistor models are from: The Development of Bipolar Log-Domain Filters in a Standard CMOS Process, G. D. Duerden, G. W. Roberts, M. J. Deen, 2001

// Release:
// 	version 1.1

// VerilogA for phy_local, va_prbs_checker, veriloga

`include "constants.vams"
`include "disciplines.vams"

module va_prbs_checker(counter_pass_ao, error_o, clk_i, data_i, enable_i);
output error_o;
electrical error_o;
input clk_i;
electrical clk_i;
input [15:0] data_i;
electrical [15:0] data_i;
input enable_i;
electrical enable_i;
output counter_pass_ao;
electrical counter_pass_ao;

parameter real vhigh = 1.5;
parameter real trf = 30p;
parameter integer skipFirstXClks = 6; // The first 6 clocks have to be skipped!

integer register      [15:0] = {0,0,0,0,0,0,0,0,0,0,0,0,0,0,0,0};
integer register_next [15:0] = {0,0,0,0,0,0,0,0,0,0,0,0,0,0,0,0};

integer internal_state      [8:0] = {0,0,0,0,0,0,0,0,0};

integer i = 0;
integer j = 0;
integer tmp = 0;

integer fail = 1;
integer initialize = 1;
integer skippedClks = 0;

integer counterPassed = 0;

/*
* Checking bytes on rising edge of clk!
*/
analog begin

    @(cross(V(clk_i)-vhigh/2, +1)) begin
        if (V(enable_i)>vhigh/2 && skippedClks<skipFirstXClks) begin
            skippedClks = skippedClks + 1;
        end
    end

    @(cross(V(clk_i)-vhigh/2, +1)) begin
        if (V(enable_i)>vhigh/2 && skippedClks>=skipFirstXClks) begin
            if (initialize==1) begin
                // Extract internal state
                internal_state[0] =  V(data_i[15])>vhigh/2;
                internal_state[1] =  V(data_i[14])>vhigh/2;
                internal_state[2] =  V(data_i[13])>vhigh/2;
                internal_state[3] =  V(data_i[12])>vhigh/2;
                internal_state[4] =  V(data_i[11])>vhigh/2;
                internal_state[5] =  V(data_i[10])>vhigh/2;
                internal_state[6] =  V(data_i[ 9])>vhigh/2;
                internal_state[7] =  V(data_i[ 8])>vhigh/2;
                internal_state[8] =  V(data_i[ 7])>vhigh/2;

                // Make sure that at least one bit of the internal state is != 0!
                // This makes sure, that we are not in the 0 state...
                tmp = 0;
                for (i = 0; i<9; i=i+1) begin
                    if (internal_state[i]!=0) begin
                       tmp = 1;
                    end
                end
                if (tmp) begin
                    initialize = 0;
                end
                counterPassed = 0;
            end else begin

                $strobe("Internal State before running the prbs  : %d.%d%d%d%d.%d%d%d%d",
                        internal_state[8],
                        internal_state[7],
                        internal_state[6],
                        internal_state[5],
                        internal_state[4],
                        internal_state[3],
                        internal_state[2],
                        internal_state[1],
                        internal_state[0]
                        );

                for (j = 0; j<16; j=j+1) begin

                    tmp = (internal_state[4]^internal_state[8]);
                    // Shift one in direction of MSB
                    for (i = 7; i>=0; i=i-1) begin
                        internal_state[i+1] = internal_state[i];
                    end
                    internal_state[0] = tmp;
                    register_next[j] = internal_state[0];
                end

                $strobe("Expected: %d%d%d%d.%d%d%d%d.%d%d%d%d.%d%d%d%d",
                        register_next[15],
                        register_next[14],
                        register_next[13],
                        register_next[12],
                        register_next[11],
                        register_next[10],
                        register_next[9],
                        register_next[8],
                        register_next[7],
                        register_next[6],
                        register_next[5],
                        register_next[4],
                        register_next[3],
                        register_next[2],
                        register_next[1],
                        register_next[0]
                        );

                // store input value to register
                register[0] =  V(data_i[ 0])>vhigh/2;
                register[1] =  V(data_i[ 1])>vhigh/2;
                register[2] =  V(data_i[ 2])>vhigh/2;
                register[3] =  V(data_i[ 3])>vhigh/2;
                register[4] =  V(data_i[ 4])>vhigh/2;
                register[5] =  V(data_i[ 5])>vhigh/2;
                register[6] =  V(data_i[ 6])>vhigh/2;
                register[7] =  V(data_i[ 7])>vhigh/2;
                register[8] =  V(data_i[ 8])>vhigh/2;
                register[9] =  V(data_i[ 9])>vhigh/2;
                register[10] = V(data_i[10])>vhigh/2;
                register[11] = V(data_i[11])>vhigh/2;
                register[12] = V(data_i[12])>vhigh/2;
                register[13] = V(data_i[13])>vhigh/2;
                register[14] = V(data_i[14])>vhigh/2;
                register[15] = V(data_i[15])>vhigh/2;

                $strobe("Got     : %d%d%d%d.%d%d%d%d.%d%d%d%d.%d%d%d%d",
                        register[15],
                        register[14],
                        register[13],
                        register[12],
                        register[11],
                        register[10],
                        register[9],
                        register[8],
                        register[7],
                        register[6],
                        register[5],
                        register[4],
                        register[3],
                        register[2],
                        register[1],
                        register[0]
                        );
                // check if register == register_next
                fail = 0;
                for (i = 0; i<15; i=i+1) begin
                    if (register[i]!=register_next[i]) begin
                        fail = 1;
                        initialize = 1;
                    end
                end
                if (fail==1) begin
                    counterPassed = 0;
                    $strobe("[FAIL] PRBS check failed! va_prbs_checker will try to sync again...");
                end else begin
                    counterPassed = counterPassed + 1;
                    $strobe("[PASS] PRBS check OK! #%d", counterPassed);
                end
            end
        end
    end
end

/*
* Set outputs
*/
analog begin

    V(counter_pass_ao) <+ transition(counterPassed/1000.0,0,trf,trf); // scale counterPassed (1mV = 1 pass -> 511mV = 511 pass and then finished)
    V(error_o) <+ transition(vhigh*fail,0,trf,trf);
end

endmodule
