// Disclaimer:
// THIS FILE IS PROVIDED AS IS AND WITH:
// (A) NO WARRANTY OF ANY KIND, express, implied or statutory, including any implied warranties of merchantability, fitness for a particular purpose and noninfringement, which  Infineon disclaims to the maximum extent permitted by applicable law; and
// (B) NO INDEMNIFICATION FOR INFRINGEMENT OF INTELLECTUAL PROPERTY RIGHTS.
// (C) LIMITATION OF LIABILITY: IN NO EVENT SHALL INFINEON BE LIABLE FOR ANY DIRECT, INDIRECT, SPECIAL, INCIDENTAL, OR CONSEQUENTIAL DAMAGES (INCLUDING LOST PROFITS OR SAVINGS) WHATSOEVER, WHETHER BASED ON CONTRACT, TORT OR ANY OTHER LEGAL THEORY, EVEN IF ADVISED OF THE POSSIBILITY OF SUCH DAMAGES.
// © 2020 Infineon Technologies AG. All rights reserved.

// Note:
// The CMOS transistor models used, were freely available models downloaded from: http://ptm.asu.edu.
// The bipolar transistor models are from: The Development of Bipolar Log-Domain Filters in a Standard CMOS Process, G. D. Duerden, G. W. Roberts, M. J. Deen, 2001

// Release:
// 	version 1.1

/**
* LPTX
* ----------
* Applying a 25 MHz clock (0/1/0) to all outputs (no termination) and measure eye diagram
*/

/*
* Parameters
*/
parameter real lptx_freq = 25e6;
parameter real lptx_rise_fall_max_ns = (85.0-15.0)/(80.0-20.0)*25;
parameter real lptx_h_min = 0.95;
parameter real lptx_h_max = 1.3;

/*
* Variables
*/
real lptx_next_clk_event = -1;
real lptx_delay_mode0 = 0;

/*
* Clk generator
*/
analog begin
    @(timer( lptx_next_clk_event )) begin
        if (state == STATE_LPTX ) begin

            if (mode[0] == MODE_FORCE_LPTX_P0N1) begin
                for (i = 0; i<5; i=i+1) begin
                    mode[i] = MODE_FORCE_LPTX_P1N0;
                end
            end else begin
                for (i = 0; i<5; i=i+1) begin
                    mode[i] = MODE_FORCE_LPTX_P0N1;
                end
            end
            lptx_next_clk_event = $abstime + 1/lptx_freq/2;
        end
    end
end

/*
* Waiting for ready signal and then do the evaluation
*/
analog begin

    @( cross(V(waveform_read_i[0])-vhigh/2, +1)
    or cross(V(waveform_read_i[1])-vhigh/2, +1)
    or cross(V(waveform_read_i[2])-vhigh/2, +1)
    or cross(V(waveform_read_i[3])-vhigh/2, +1)) begin
        if (state == STATE_LPTX
        && V(waveform_read_i[0])>vhigh/2
        && V(waveform_read_i[1])>vhigh/2
        && V(waveform_read_i[2])>vhigh/2
        && V(waveform_read_i[3])>vhigh/2) begin
            $strobe("-> All lanes are now ready! <-");

            if (V(yopen0_ai[0]) > lptx_h_max || V(yopen0_ai[0]) < lptx_h_min) begin
                $strobe("[FAIL] LPTX of lane %d is outputting a voltage which is out of the range of %f V to %f V",
                0, lptx_h_min, lptx_h_max);
                fail = 1;
                next_state_time = $abstime + 1n;
            end
            if (V(yopen0_ai[1]) > lptx_h_max || V(yopen0_ai[1]) < lptx_h_min) begin
                $strobe("[FAIL] LPTX of lane %d is outputting a voltage which is out of the range of %f V to %f V",
                1, lptx_h_min, lptx_h_max);
                fail = 1;
                next_state_time = $abstime + 1n;
            end
            if (V(yopen0_ai[2]) > lptx_h_max || V(yopen0_ai[2]) < lptx_h_min) begin
                $strobe("[FAIL] LPTX of lane %d is outputting a voltage which is out of the range of %f V to %f V",
                2, lptx_h_min, lptx_h_max);
                fail = 1;
                next_state_time = $abstime + 1n;
            end
            if (V(yopen0_ai[3]) > lptx_h_max || V(yopen0_ai[3]) < lptx_h_min) begin
                $strobe("[FAIL] LPTX of lane %d is outputting a voltage which is out of the range of %f V to %f V",
                3, lptx_h_min, lptx_h_max);
                fail = 1;
                next_state_time = $abstime + 1n;
            end

            if (V(yopen1_ai[0]) > lptx_h_max || V(yopen1_ai[0]) < lptx_h_min) begin
                $strobe("[FAIL] LPTX of lane %d is outputting a voltage which is out of the range of %f V to %f V",
                0, lptx_h_min, lptx_h_max);
                fail = 1;
                next_state_time = $abstime + 1n;
            end
            if (V(yopen1_ai[1]) > lptx_h_max || V(yopen1_ai[1]) < lptx_h_min) begin
                $strobe("[FAIL] LPTX of lane %d is outputting a voltage which is out of the range of %f V to %f V",
                1, lptx_h_min, lptx_h_max);
                fail = 1;
                next_state_time = $abstime + 1n;
            end
            if (V(yopen1_ai[2]) > lptx_h_max || V(yopen1_ai[2]) < lptx_h_min) begin
                $strobe("[FAIL] LPTX of lane %d is outputting a voltage which is out of the range of %f V to %f V",
                2, lptx_h_min, lptx_h_max);
                fail = 1;
                next_state_time = $abstime + 1n;
            end
            if (V(yopen1_ai[3]) > lptx_h_max || V(yopen1_ai[3]) < lptx_h_min) begin
                $strobe("[FAIL] LPTX of lane %d is outputting a voltage which is out of the range of %f V to %f V",
                3, lptx_h_min, lptx_h_max);
                fail = 1;
                next_state_time = $abstime + 1n;
            end

            if (V(rise_ai[0]) > lptx_rise_fall_max_ns || V(fall_ai[0]) > lptx_rise_fall_max_ns) begin
                $strobe("[FAIL] LPTX of lane %d rises (%f ns) or falls (%f ns) faster than %f ns!",
                0, V(rise_ai[0]) , V(fall_ai[0]), lptx_rise_fall_max_ns );
                fail = 1;
                next_state_time = $abstime + 1n;
            end
            if (V(rise_ai[1]) > lptx_rise_fall_max_ns || V(fall_ai[1]) > lptx_rise_fall_max_ns) begin
                $strobe("[FAIL] LPTX of lane %d rises (%f ns) or falls (%f ns) faster than %f ns!",
                1, V(rise_ai[1]) , V(fall_ai[1]), lptx_rise_fall_max_ns );
                fail = 1;
                next_state_time = $abstime + 1n;
            end
            if (V(rise_ai[2]) > lptx_rise_fall_max_ns || V(fall_ai[2]) > lptx_rise_fall_max_ns) begin
                $strobe("[FAIL] LPTX of lane %d rises (%f ns) or falls (%f ns) faster than %f ns!",
                2, V(rise_ai[2]) , V(fall_ai[2]), lptx_rise_fall_max_ns );
                fail = 1;
                next_state_time = $abstime + 1n;
            end
            if (V(rise_ai[3]) > lptx_rise_fall_max_ns || V(fall_ai[3]) > lptx_rise_fall_max_ns) begin
                $strobe("[FAIL] LPTX of lane %d rises (%f ns) or falls (%f ns) faster than %f ns!",
                3, V(rise_ai[3]) , V(fall_ai[3]), lptx_rise_fall_max_ns );
                fail = 1;
                next_state_time = $abstime + 1n;
            end

            if (fail!=1) begin
                $strobe("[PASS] LPTX check done");
                // Continue with the next test
                next_state_time = $abstime + trf;
                state = state + 1;
            end

        end
    end
end

/*
* Main entry point
*/
analog begin
    @(timer( next_state_time )) begin
        if (state == STATE_LPTX ) begin

            $strobe("-> Check LPTX operation and characteristics <-");

            /*
            * Common signals
            */
            for (i = 0; i<4; i=i+1) begin
                dft_ana_test_out_dphy_sel[i] = 0;
            end

            for (i = 0; i<3; i=i+1) begin
                hstx_lower_imp_cal[i] = 0;
                hstx_upper_imp_cal[i] = 0;
            end

            dft_ana_test_en         = 1; // Enable analog test path (so that we can observe the LDO voltage)
            dft_dphy_ocdldo_res_dis = 0; // Load resistor for HSTX LDO to keep it stable during LPTX transmission
            dft_pll_clks_2_cl_en    = 0; // route back the divided clock and the reference clock via DL1 and CL
            dft_scan_mode           = 0;
            en_clk_dphy             = 0; // Enable high speed clock for serializer
            sel_dr                  = 0; // 0 = 1 Gbps, 1 = 2 Gbps
            hstx_en_fast_trf        = 0; // 0 = slow rise/fall (1 Gbps), 1 = fast rise/fall (2 Gbps)
            en_clk_byte             = 1; // Enabled byte clock (derived from DL1), used for syncing the PRBS
            en_bias                 = 1;
            dphy_pwrdn              = 0;
            dphy_reset_n            = 1;
            en_iso_vddphy           = 1; // 1 = Disable isolation of digital control signals
            en_ls_vddphy            = 1; // enable bias currents
            hs_ser_msb_first_en     = 0; // 0 = LSB first, 1 = MSB first
            termination_en          = 0; // Enable termination resistor

            // Enable one of the lane outputs with the LPTX channel
            for (i = 0; i<5; i=i+1) begin
                mode[i] = MODE_FORCE_LPTX_P0N1;
            end

            // Reset the waveform analyzer
            waveform_analyzer_en = 0;
            waveform_analyzer_ideal_min_max = 1;
            waveform_analyzer_en_pulse_start = $abstime+5n;

            lptx_delay_mode0 = 1/lptx_freq/4;               // Delay clock lane
            lptx_next_clk_event = $abstime + 1/lptx_freq/2; // Normal timer event for signal generation
        end
    end
end
