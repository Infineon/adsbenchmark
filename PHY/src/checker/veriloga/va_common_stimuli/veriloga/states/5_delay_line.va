// Disclaimer:
// THIS FILE IS PROVIDED AS IS AND WITH:
// (A) NO WARRANTY OF ANY KIND, express, implied or statutory, including any implied warranties of merchantability, fitness for a particular purpose and noninfringement, which  Infineon disclaims to the maximum extent permitted by applicable law; and
// (B) NO INDEMNIFICATION FOR INFRINGEMENT OF INTELLECTUAL PROPERTY RIGHTS.
// (C) LIMITATION OF LIABILITY: IN NO EVENT SHALL INFINEON BE LIABLE FOR ANY DIRECT, INDIRECT, SPECIAL, INCIDENTAL, OR CONSEQUENTIAL DAMAGES (INCLUDING LOST PROFITS OR SAVINGS) WHATSOEVER, WHETHER BASED ON CONTRACT, TORT OR ANY OTHER LEGAL THEORY, EVEN IF ADVISED OF THE POSSIBILITY OF SUCH DAMAGES.
// © 2020 Infineon Technologies AG. All rights reserved.

// Note:
// The CMOS transistor models used, were freely available models downloaded from: http://ptm.asu.edu.
// The bipolar transistor models are from: The Development of Bipolar Log-Domain Filters in a Standard CMOS Process, G. D. Duerden, G. W. Roberts, M. J. Deen, 2001

// Release:
// 	version 1.0

/**
* Delay Line Test
* ---------------
* Measure delay relativly to clock.
* Setup one delay setting after each other (same setting for each lane except the clock lane that is kept constant).
* Measure the introduced time delay.
* Then, setup all delay settings of the clock and keep the settings of the others constant.
* Measure the introduced time delay.
*
* Each delay is measured for N periods. N/2 is done for the rising edges and N/2 for the falling edges.
* We must make sure that the delay line is working properly for both edges.
*/

/*
* Parameters
*/
parameter real delay_line_measure_time = 150n; // How long do we measure the skew?
parameter real delay_line_acceptable_dt_rel = 0.2; // Accept +-20% difference of the skew
parameter real pll_max_lock_time = 5u; // Wait this time for locking signal, otherwise throw error
parameter real pll_wait_time = 4u;
parameter real delay_ready_timeout = 500n; // If result of waveform analyzer is not there by this time, exit! Probably there is no clock.

/*
* Variables (there are no 2d arrays in verilog-a)
*/
integer delay_line_start_listening_for_result = 0;
real delay_line_reset_timer_pulse_start = -1;
real delay_line_reset_timer_pulse_end = -1;

`define DELAY_LINE_NUM_ROWS 15
`define DELAY_LINE_NUM_ELEMENTS (`DELAY_LINE_NUM_ROWS*3-1)
real delay_line_measurement_settings[0:`DELAY_LINE_NUM_ELEMENTS] = {
        // Delay Lanes | Delay Clk | falling/rising target
        // Testing lanes
                0,          0,           0.5,
        // Check difference of one to another
                0,          1,           0.5+0.06,
                1,          2,           0.5+0.06,
                2,          3,           0.5+0.06,
                3,          4,           0.5+0.06,
                4,          5,           0.5+0.06,
                5,          6,           0.5+0.06,
                6,          7,           0.5+0.06,
        // Check equivalence of all
                1,          1,           0.5,
                2,          2,           0.5,
                3,          3,           0.5,
                4,          4,           0.5,
                5,          5,           0.5,
                6,          6,           0.5,
                7,          7,           0.5
};
real delay_line_setup_state_next = -1;
real delay_line_target = -1;
integer delay_line_pointer = 0;

real delay_pll_lock_fail_timer = -1;

real delay_timeout = -1;

analog begin
    @(timer( delay_timeout )) begin
        $strobe("[INFO] FAIL delay line test! Timeout reached. Maybe there is no clock?");
        fail = 1;
        next_state_time = $abstime + 1p;
    end
end

/*
* Setup state
*/
analog begin
    @(timer( delay_line_setup_state_next )) begin
        if (state == STATE_HSTX_DELAY_LINE ) begin

            delay_timeout = $abstime + delay_ready_timeout; // Setup timeout

            en_clk_dphy             = 1; // Enable clock
            for (i = 0; i<5; i=i+1) begin
                mode[i] = MODE_010;
            end

            if (delay_line_pointer>=`DELAY_LINE_NUM_ELEMENTS) begin
                // End reached and all passed
                $strobe("[PASS] Delay line complete");
                // Continue with the next test
                next_state_time = $abstime + trf;
                state = state + 1;
                delay_timeout = -1; // Remove timeout

            end else begin
                // Setup according to matrix
                $strobe("[INFO] Delay lines setup -> waiting for result from waveform analyzer");
                // First all lanes
                for (i = 1; i<5; i=i+1) begin
                    delay[i] = delay_line_measurement_settings[delay_line_pointer];
                end
                delay_line_pointer = delay_line_pointer + 1;
                // Then set the clock lane
                delay[0] = delay_line_measurement_settings[delay_line_pointer];
                delay_line_pointer = delay_line_pointer + 1;

                // Reset timer for skew measurement, then register next time
                delay_line_reset_timer_pulse_start = $abstime + 2n + trf;
                delay_line_start_listening_for_result = 0;
            end
        end
    end
end

/*
* Measure output of measure analyzer
*/
analog begin

    @( cross(V(waveform_read_i[0])-vhigh/2, +1)
    or cross(V(waveform_read_i[1])-vhigh/2, +1)
    or cross(V(waveform_read_i[2])-vhigh/2, +1)
    or cross(V(waveform_read_i[3])-vhigh/2, +1)) begin
        if (state == STATE_HSTX_DELAY_LINE
        && delay_line_start_listening_for_result==1
        && V(waveform_read_i[0])>vhigh/2
        && V(waveform_read_i[1])>vhigh/2
        && V(waveform_read_i[2])>vhigh/2
        && V(waveform_read_i[3])>vhigh/2) begin
            delay_line_start_listening_for_result = 0;

            delay_line_target = delay_line_measurement_settings[delay_line_pointer];
            delay_line_pointer = delay_line_pointer + 1;

            /////////////////////////////////
                $strobe("=============");
                $strobe("[INFO] Progress: %d/%d", delay_line_pointer, `DELAY_LINE_NUM_ELEMENTS);
                $strobe("[INFO] Lane: %d", 0);
                $strobe("[INFO] Expect: %f ns", delay_line_target);
                $strobe("[INFO] Got: %f ns", V(xopen0_ai[0]));
                $strobe("[INFO] And got: %f ns", V(xopen1_ai[0]));
                $strobe("[INFO] Sum: %f ns", V(xopen0_ai[0])+V(xopen1_ai[0]));
                $strobe("[INFO] UI: %f ns", V(UI_ai[0]));

                if (
                    (  V(xopen0_ai[0]) < delay_line_target*(1+delay_line_acceptable_dt_rel)
                    && V(xopen0_ai[0]) > delay_line_target*(1-delay_line_acceptable_dt_rel))
                    ||
                    (  V(xopen1_ai[0]) < delay_line_target*(1+delay_line_acceptable_dt_rel)
                    && V(xopen1_ai[0]) > delay_line_target*(1-delay_line_acceptable_dt_rel))
                    ) begin
                    $strobe("[INFO] PASS delay line");
                end else begin
                    $strobe("[INFO] FAIL delay line test");
                    fail = 1;
                    next_state_time = $abstime + 1p;
                end

                $strobe("=============");
            /////////////////////////////////

            /////////////////////////////////
                $strobe("=============");
                $strobe("[INFO] Progress: %d/%d", delay_line_pointer, `DELAY_LINE_NUM_ELEMENTS);
                $strobe("[INFO] Lane: %d", 1);
                $strobe("[INFO] Expect: %f ns", delay_line_target);
                $strobe("[INFO] Got: %f ns", V(xopen0_ai[1]));
                $strobe("[INFO] And got: %f ns", V(xopen1_ai[1]));
                $strobe("[INFO] Sum: %f ns", V(xopen0_ai[1])+V(xopen1_ai[1]));
                $strobe("[INFO] UI: %f ns", V(UI_ai[1]));

                if (
                    (  V(xopen0_ai[1]) < delay_line_target*(1+delay_line_acceptable_dt_rel)
                    && V(xopen0_ai[1]) > delay_line_target*(1-delay_line_acceptable_dt_rel))
                    ||
                    (  V(xopen1_ai[1]) < delay_line_target*(1+delay_line_acceptable_dt_rel)
                    && V(xopen1_ai[1]) > delay_line_target*(1-delay_line_acceptable_dt_rel))
                    ) begin
                    $strobe("[INFO] PASS delay line");
                end else begin
                    $strobe("[INFO] FAIL delay line test");
                    fail = 1;
                    next_state_time = $abstime + 1p;
                end

                $strobe("=============");
            /////////////////////////////////

            /////////////////////////////////
                $strobe("=============");
                $strobe("[INFO] Progress: %d/%d", delay_line_pointer, `DELAY_LINE_NUM_ELEMENTS);
                $strobe("[INFO] Lane: %d", 2);
                $strobe("[INFO] Expect: %f ns", delay_line_target);
                $strobe("[INFO] Got: %f ns", V(xopen0_ai[2]));
                $strobe("[INFO] And got: %f ns", V(xopen1_ai[2]));
                $strobe("[INFO] Sum: %f ns", V(xopen0_ai[2])+V(xopen1_ai[2]));
                $strobe("[INFO] UI: %f ns", V(UI_ai[2]));

                if (
                    (  V(xopen0_ai[2]) < delay_line_target*(1+delay_line_acceptable_dt_rel)
                    && V(xopen0_ai[2]) > delay_line_target*(1-delay_line_acceptable_dt_rel))
                    ||
                    (  V(xopen1_ai[2]) < delay_line_target*(1+delay_line_acceptable_dt_rel)
                    && V(xopen1_ai[2]) > delay_line_target*(1-delay_line_acceptable_dt_rel))
                    ) begin
                    $strobe("[INFO] PASS delay line");
                end else begin
                    $strobe("[INFO] FAIL delay line test");
                    fail = 1;
                    next_state_time = $abstime + 1p;
                end

                $strobe("=============");
            /////////////////////////////////

            /////////////////////////////////
                $strobe("=============");
                $strobe("[INFO] Progress: %d/%d", delay_line_pointer, `DELAY_LINE_NUM_ELEMENTS);
                $strobe("[INFO] Lane: %d", 3);
                $strobe("[INFO] Expect: %f ns", delay_line_target);
                $strobe("[INFO] Got: %f ns", V(xopen0_ai[3]));
                $strobe("[INFO] And got: %f ns", V(xopen1_ai[3]));
                $strobe("[INFO] Sum: %f ns", V(xopen0_ai[3])+V(xopen1_ai[3]));
                $strobe("[INFO] UI: %f ns", V(UI_ai[3]));

                if (
                    (  V(xopen0_ai[3]) < delay_line_target*(1+delay_line_acceptable_dt_rel)
                    && V(xopen0_ai[3]) > delay_line_target*(1-delay_line_acceptable_dt_rel))
                    ||
                    (  V(xopen1_ai[3]) < delay_line_target*(1+delay_line_acceptable_dt_rel)
                    && V(xopen1_ai[3]) > delay_line_target*(1-delay_line_acceptable_dt_rel))
                    ) begin
                    $strobe("[INFO] PASS delay line");
                end else begin
                    $strobe("[INFO] FAIL delay line test");
                    fail = 1;
                    next_state_time = $abstime + 1p;
                end

                $strobe("=============");
            /////////////////////////////////

            // Continue with the next test
            delay_line_setup_state_next = $abstime + trf;
        end
    end

end

/*
* Creating reset pulse for waveform analyzer measurement block
*/
analog begin
    @(timer(delay_line_reset_timer_pulse_start)) begin
        waveform_analyzer_en = 0;
        delay_line_reset_timer_pulse_end = $abstime+trf;
    end
    @(timer(delay_line_reset_timer_pulse_end)) begin
        waveform_analyzer_en = 1;
        delay_line_start_listening_for_result = 1; // Now start listening!
    end
end

/*
* Main entry point
*/
analog begin
    @(timer( next_state_time )) begin
        if (state == STATE_HSTX_DELAY_LINE ) begin

            $strobe("-> Check Delay Line of HSTX <-");

            /*
            * Common signals
            */
            for (i = 0; i<4; i=i+1) begin
                dft_ana_test_out_dphy_sel[i] = 0;
            end

            for (i = 0; i<3; i=i+1) begin
                hstx_lower_imp_cal[i] = 0;
                hstx_upper_imp_cal[i] = 0;
            end

            for (i = 0; i<5; i=i+1) begin
                lptx_vref_prog[i] = 0;
            end
            lptx_vref_prog[2] = 1; // 1.2V vref without offset

            dft_ana_test_en         = 0; // Disable analog test path
            dft_dphy_ocdldo_res_dis = 0; // Load resistor for HSTX LDO to keep it stable during LPTX transmission
            dft_pll_clks_2_cl_en    = 0; // route back the divided clock and the reference clock via DL1 and CL
            dft_scan_mode           = 0;
            en_clk_dphy             = 0; // Enable high speed clock for serializer
            sel_dr                  = 0; // 0 = 1 Gbps, 1 = 2 Gbps
            hstx_en_fast_trf        = 0; // 0 = slow rise/fall (1 Gbps), 1 = fast rise/fall (2 Gbps)
            en_clk_byte             = 1; // Enabled byte clock (derived from DL1), used for syncing the PRBS
            en_bias                 = 1;
            dphy_pwrdn              = 0;
            dphy_reset_n            = 1;
            en_iso_vddphy           = 1; // 1 = Disable isolation of digital control signals
            en_ls_vddphy            = 1; // enable bias currents
            hs_ser_msb_first_en     = 0; // 0 = LSB first, 1 = MSB first

            termination_en          = 1;
            waveform_analyzer_ideal_min_max = 1; // Speed up the delay measurement much

            // Enable lane outputs with 010
            for (i = 0; i<5; i=i+1) begin
                mode[i] = MODE_IDLE_HSTX; // First just idle -> when locked 010 mode
                delay[i] = 0; // 0 delay
            end

            en_1GHz_quad = 1;  // Enable 1 GHz clock

            $strobe("[INFO] PLL starting up");
            delay_pll_lock_fail_timer = $abstime + pll_max_lock_time;
        end
    end
end

/*
* Wait until pll has locked -> from now on the pll will be continuously running till the end of the test!
*/
analog begin
    @(cross(V(clk_okay_i)-vhigh/2, +1)) begin
        if (state == STATE_HSTX_DELAY_LINE ) begin
            $strobe("[INFO] PLL has locked and outputs now a valid 4 phase clock.");
            // Start the measurement
            delay_line_setup_state_next = $abstime+trf+pll_wait_time;
            delay_line_start_listening_for_result = 0;
            delay_pll_lock_fail_timer = -1;
        end
    end
end

analog begin
    @(timer( delay_pll_lock_fail_timer )) begin
        if (state == STATE_HSTX_DELAY_LINE ) begin
            $strobe("[FAIL] PLL is not locking fast enough!");
            fail = 1;
            next_state_time = $abstime + 1n;
        end
    end
end
