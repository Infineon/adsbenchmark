// Disclaimer:
// THIS FILE IS PROVIDED AS IS AND WITH:
// (A) NO WARRANTY OF ANY KIND, express, implied or statutory, including any implied warranties of merchantability, fitness for a particular purpose and noninfringement, which  Infineon disclaims to the maximum extent permitted by applicable law; and
// (B) NO INDEMNIFICATION FOR INFRINGEMENT OF INTELLECTUAL PROPERTY RIGHTS.
// (C) LIMITATION OF LIABILITY: IN NO EVENT SHALL INFINEON BE LIABLE FOR ANY DIRECT, INDIRECT, SPECIAL, INCIDENTAL, OR CONSEQUENTIAL DAMAGES (INCLUDING LOST PROFITS OR SAVINGS) WHATSOEVER, WHETHER BASED ON CONTRACT, TORT OR ANY OTHER LEGAL THEORY, EVEN IF ADVISED OF THE POSSIBILITY OF SUCH DAMAGES.
// © 2020 Infineon Technologies AG. All rights reserved.

// Note:
// The CMOS transistor models used, were freely available models downloaded from: http://ptm.asu.edu.
// The bipolar transistor models are from: The Development of Bipolar Log-Domain Filters in a Standard CMOS Process, G. D. Duerden, G. W. Roberts, M. J. Deen, 2001

// Release:
// 	version 1.0

/**
* HSTX PRBS
* ----------
* Send a prbs in
* Check the feedback PRBS (checking serializer/deserializer)
*/

/*
* Variables
*/
integer hstx_prbs_fail = 1;
integer hstx_prbs_lane_out_fail = 1;
real hstx_prbs_started = 10000;

/*
* Observe fail outputs of lane_stimuli to check if an error happened
*/
analog begin
    if (state == STATE_HSTX_PRBS && hstx_prbs_started<$abstime) begin
        //  Don't check the clock, since it is just in 010 mode not in prbs!
        hstx_prbs_fail =  (V(loopback_prbs_checker_err_i[1])>vhigh/2)
                        || (V(loopback_prbs_checker_err_i[2])>vhigh/2)
                        || (V(loopback_prbs_checker_err_i[3])>vhigh/2)
                        || (V(loopback_prbs_checker_err_i[4])>vhigh/2);
        hstx_prbs_lane_out_fail =  (V(output_prbs_checker_error_i[1])>vhigh/2)
                        || (V(output_prbs_checker_error_i[2])>vhigh/2)
                        || (V(output_prbs_checker_error_i[3])>vhigh/2)
                        || (V(output_prbs_checker_error_i[4])>vhigh/2);

    end
    // Trigger
    @(cross(hstx_prbs_lane_out_fail-0.5, +1)) begin
        if (state == STATE_HSTX_PRBS && hstx_prbs_started<$abstime ) begin

                $strobe("[FAIL] A bit was corrupted! Lane output loopback detected a problem (%d,%d,%d,%d).",
                        (V(output_prbs_checker_error_i[1])>vhigh/2),
                        (V(output_prbs_checker_error_i[2])>vhigh/2),
                        (V(output_prbs_checker_error_i[3])>vhigh/2),
                        (V(output_prbs_checker_error_i[4])>vhigh/2));
                fail = 1;
                next_state_time = $abstime+1p;
        end
    end
    @(cross(hstx_prbs_fail-0.5, +1)) begin
        if (state == STATE_HSTX_PRBS && hstx_prbs_started<$abstime ) begin

                $strobe("[FAIL] A bit was corrupted! Serializer loopback detected a problem (%d,%d,%d,%d,%d).",
                        (V(loopback_prbs_checker_err_i[0])>vhigh/2),
                        (V(loopback_prbs_checker_err_i[1])>vhigh/2),
                        (V(loopback_prbs_checker_err_i[2])>vhigh/2),
                        (V(loopback_prbs_checker_err_i[3])>vhigh/2),
                        (V(loopback_prbs_checker_err_i[4])>vhigh/2));
                fail = 1;
                next_state_time = $abstime+1p;
        end
    end

    @(cross(V(output_prbs_checker_counter_ai[4])-512m, +1)) begin
        if (state == STATE_HSTX_PRBS && hstx_prbs_started<$abstime ) begin
            // End reached and all passed
            $strobe("[PASS] PRBS completed without errors");
            // Continue with the next test
            next_state_time = $abstime + trf;
            state = state + 1;
        end
    end

end

/*
* Evaluating waveform analyzer
*/
parameter real T_EYE_TX_LOWER_LIMIT = 0.5;
parameter real V_DIF_TX_LOWER_LIMIT = 40m; // in mV
parameter real TRF_MAX = 0.35; // * UI
parameter real TRF_MIN = 0.1; // Minimum trf in ns
real T_EYE_TX = 0;
real V_DIF_TX_H = 0;
real V_DIF_TX_L = 0;
real UI_HS = 0;
real TRF_TMP = 0;
analog begin
    @( cross(V(waveform_read_i[0])-vhigh/2, +1)) begin
        if (fail == 0 && hstx_prbs_started<$abstime) begin
            if (state == STATE_HSTX_PRBS ) begin
                UI_HS = V(UI_ai[0]);

                TRF_TMP = V(rise_ai[0]);
                if (TRF_TMP > TRF_MAX*UI_HS) begin
                    $strobe("[FAIL] Lane 1) Rise time = %f ns larger than max %f ns", TRF_TMP, TRF_MAX*UI_HS);
                    fail = 1;
                    next_state_time = $abstime+1p;
                end
                if (TRF_TMP < TRF_MIN) begin
                    $strobe("[FAIL] Lane 1) Rise time = %f ns lower than max %f ns", TRF_TMP, TRF_MIN);
                    fail = 1;
                    next_state_time = $abstime+1p;
                end

                TRF_TMP = V(fall_ai[0]);
                if (TRF_TMP > TRF_MAX*UI_HS) begin
                    $strobe("[FAIL] Lane 1) Fall time = %f ns larger than max %f ns", TRF_TMP, TRF_MAX*UI_HS);
                    fail = 1;
                    next_state_time = $abstime+1p;
                end
                if (TRF_TMP < TRF_MIN) begin
                    $strobe("[FAIL] Lane 1) Fall time = %f ns lower than max %f ns", TRF_TMP, TRF_MIN);
                    fail = 1;
                    next_state_time = $abstime+1p;
                end

                T_EYE_TX = V(xopen0_ai[0]) + V(xopen1_ai[0]);
                if (T_EYE_TX < T_EYE_TX_LOWER_LIMIT*UI_HS) begin
                    $strobe("[FAIL] Lane 1) T_EYE_TX = %f ns too small (< %f ns)", T_EYE_TX, T_EYE_TX_LOWER_LIMIT*UI_HS);
                    fail = 1;
                    next_state_time = $abstime+1p;
                end

                V_DIF_TX_H = V(yopen1_ai[0]);
                V_DIF_TX_L = V(yopen0_ai[0]);
                if (V_DIF_TX_H < V_DIF_TX_LOWER_LIMIT) begin
                    $strobe("[FAIL] Lane 1) V_DIF_TX_H = %f V (< %f V)", V_DIF_TX_H, V_DIF_TX_LOWER_LIMIT);
                    fail = 1;
                    next_state_time = $abstime+1p;
                end
                if (V_DIF_TX_L < V_DIF_TX_LOWER_LIMIT) begin
                    $strobe("[FAIL] Lane 1) V_DIF_TX_H = %f V (< %f V)", V_DIF_TX_H, V_DIF_TX_LOWER_LIMIT);
                    fail = 1;
                    next_state_time = $abstime+1p;
                end

            end
        end
    end

    @( cross(V(waveform_read_i[1])-vhigh/2, +1)) begin
        if (fail == 0 && hstx_prbs_started<$abstime) begin
            if (state == STATE_HSTX_PRBS ) begin
                UI_HS = V(UI_ai[1]);

                TRF_TMP = V(rise_ai[1]);
                if (TRF_TMP > TRF_MAX*UI_HS) begin
                    $strobe("[FAIL] Lane 2) Rise time = %f ns larger than max %f ns", TRF_TMP, TRF_MAX*UI_HS);
                    fail = 1;
                    next_state_time = $abstime+1p;
                end
                if (TRF_TMP < TRF_MIN) begin
                    $strobe("[FAIL] Lane 2) Rise time = %f ns lower than max %f ns", TRF_TMP, TRF_MIN);
                    fail = 1;
                    next_state_time = $abstime+1p;
                end

                TRF_TMP = V(fall_ai[1]);
                if (TRF_TMP > TRF_MAX*UI_HS) begin
                    $strobe("[FAIL] Lane 2) Fall time = %f ns larger than max %f ns", TRF_TMP, TRF_MAX*UI_HS);
                    fail = 1;
                    next_state_time = $abstime+1p;
                end
                if (TRF_TMP < TRF_MIN) begin
                    $strobe("[FAIL] Lane 2) Fall time = %f ns lower than max %f ns", TRF_TMP, TRF_MIN);
                    fail = 1;
                    next_state_time = $abstime+1p;
                end

                T_EYE_TX = V(xopen0_ai[1]) + V(xopen1_ai[1]);
                if (T_EYE_TX < T_EYE_TX_LOWER_LIMIT*UI_HS) begin
                    $strobe("[FAIL] Lane 2) T_EYE_TX = %f ns too small (< %f ns)", T_EYE_TX, T_EYE_TX_LOWER_LIMIT*UI_HS);
                    fail = 1;
                    next_state_time = $abstime+1p;
                end
                V_DIF_TX_H = V(yopen1_ai[1]);
                V_DIF_TX_L = V(yopen0_ai[1]);
                if (V_DIF_TX_H < V_DIF_TX_LOWER_LIMIT) begin
                    $strobe("[FAIL] Lane 2) V_DIF_TX_H = %f V (< %f V)", V_DIF_TX_H, V_DIF_TX_LOWER_LIMIT);
                    fail = 1;
                    next_state_time = $abstime+1p;
                end
                if (V_DIF_TX_L < V_DIF_TX_LOWER_LIMIT) begin
                    $strobe("[FAIL] Lane 2) V_DIF_TX_H = %f V (< %f V)", V_DIF_TX_H, V_DIF_TX_LOWER_LIMIT);
                    fail = 1;
                    next_state_time = $abstime+1p;
                end

            end
        end
    end

    @( cross(V(waveform_read_i[2])-vhigh/2, +1)) begin
        if (fail == 0 && hstx_prbs_started<$abstime) begin
            if (state == STATE_HSTX_PRBS ) begin

                UI_HS = V(UI_ai[2]);

                TRF_TMP = V(rise_ai[2]);
                if (TRF_TMP > TRF_MAX*UI_HS) begin
                    $strobe("[FAIL] Lane 3) Rise time = %f ns larger than max %f ns", TRF_TMP, TRF_MAX*UI_HS);
                    fail = 1;
                    next_state_time = $abstime+1p;
                end
                if (TRF_TMP < TRF_MIN) begin
                    $strobe("[FAIL] Lane 3) Rise time = %f ns lower than max %f ns", TRF_TMP, TRF_MIN);
                    fail = 1;
                    next_state_time = $abstime+1p;
                end

                TRF_TMP = V(fall_ai[2]);
                if (TRF_TMP > TRF_MAX*UI_HS) begin
                    $strobe("[FAIL] Lane 3) Fall time = %f ns larger than max %f ns", TRF_TMP, TRF_MAX*UI_HS);
                    fail = 1;
                    next_state_time = $abstime+1p;
                end
                if (TRF_TMP < TRF_MIN) begin
                    $strobe("[FAIL] Lane 3) Fall time = %f ns lower than max %f ns", TRF_TMP, TRF_MIN);
                    fail = 1;
                    next_state_time = $abstime+1p;
                end

                T_EYE_TX = V(xopen0_ai[2]) + V(xopen1_ai[2]);
                if (T_EYE_TX < T_EYE_TX_LOWER_LIMIT*UI_HS) begin
                    $strobe("[FAIL] Lane 3) T_EYE_TX = %f ns too small (< %f ns)", T_EYE_TX, T_EYE_TX_LOWER_LIMIT*UI_HS);
                    fail = 1;
                    next_state_time = $abstime+1p;
                end
                V_DIF_TX_H = V(yopen1_ai[2]);
                V_DIF_TX_L = V(yopen0_ai[2]);
                if (V_DIF_TX_H < V_DIF_TX_LOWER_LIMIT) begin
                    $strobe("[FAIL] Lane 3) V_DIF_TX_H = %f V (< %f V)", V_DIF_TX_H, V_DIF_TX_LOWER_LIMIT);
                    fail = 1;
                    next_state_time = $abstime+1p;
                end
                if (V_DIF_TX_L < V_DIF_TX_LOWER_LIMIT) begin
                    $strobe("[FAIL] Lane 3) V_DIF_TX_H = %f V (< %f V)", V_DIF_TX_H, V_DIF_TX_LOWER_LIMIT);
                    fail = 1;
                    next_state_time = $abstime+1p;
                end

            end
        end
    end

    @( cross(V(waveform_read_i[3])-vhigh/2, +1)) begin
        if (fail == 0 && hstx_prbs_started<$abstime) begin
            if (state == STATE_HSTX_PRBS ) begin

                UI_HS = V(UI_ai[3]);
                TRF_TMP = V(rise_ai[3]);
                if (TRF_TMP > TRF_MAX*UI_HS) begin
                    $strobe("[FAIL] Lane 4) Rise time = %f ns larger than max %f ns", TRF_TMP, TRF_MAX*UI_HS);
                    fail = 1;
                    next_state_time = $abstime+1p;
                end
                if (TRF_TMP < TRF_MIN) begin
                    $strobe("[FAIL] Lane 4) Rise time = %f ns lower than max %f ns", TRF_TMP, TRF_MIN);
                    fail = 1;
                    next_state_time = $abstime+1p;
                end

                TRF_TMP = V(fall_ai[3]);
                if (TRF_TMP > TRF_MAX*UI_HS) begin
                    $strobe("[FAIL] Lane 4) Fall time = %f ns larger than max %f ns", TRF_TMP, TRF_MAX*UI_HS);
                    fail = 1;
                    next_state_time = $abstime+1p;
                end
                if (TRF_TMP < TRF_MIN) begin
                    $strobe("[FAIL] Lane 4) Fall time = %f ns lower than max %f ns", TRF_TMP, TRF_MIN);
                    fail = 1;
                    next_state_time = $abstime+1p;
                end

                T_EYE_TX = V(xopen0_ai[3]) + V(xopen1_ai[3]);
                if (T_EYE_TX < T_EYE_TX_LOWER_LIMIT*UI_HS) begin
                    $strobe("[FAIL] Lane 4) T_EYE_TX = %f ns too small (< %f ns)", T_EYE_TX, T_EYE_TX_LOWER_LIMIT*UI_HS);
                    fail = 1;
                    next_state_time = $abstime+1p;
                end
                V_DIF_TX_H = V(yopen1_ai[3]);
                V_DIF_TX_L = V(yopen0_ai[3]);
                if (V_DIF_TX_H < V_DIF_TX_LOWER_LIMIT) begin
                    $strobe("[FAIL] Lane 4) V_DIF_TX_H = %f V (< %f V)", V_DIF_TX_H, V_DIF_TX_LOWER_LIMIT);
                    fail = 1;
                    next_state_time = $abstime+1p;
                end
                if (V_DIF_TX_L < V_DIF_TX_LOWER_LIMIT) begin
                    $strobe("[FAIL] Lane 4) V_DIF_TX_H = %f V (< %f V)", V_DIF_TX_H, V_DIF_TX_LOWER_LIMIT);
                    fail = 1;
                    next_state_time = $abstime+1p;
                end

            end
        end
    end
end

/*
* Main entry point
*/
analog begin
    @(timer( next_state_time )) begin
        if (state == STATE_HSTX_PRBS ) begin

            $strobe("-> Check HSTX PRBS <-");

            /*
            * Common signals
            */
            for (i = 0; i<4; i=i+1) begin
                dft_ana_test_out_dphy_sel[i] = 0;
            end

            for (i = 0; i<3; i=i+1) begin
                hstx_lower_imp_cal[i] = 0;
                hstx_upper_imp_cal[i] = 0;
            end

            for (i = 0; i<5; i=i+1) begin
                lptx_vref_prog[i] = 0;
            end
            lptx_vref_prog[2] = 1; // 1.2V vref without offset

            dft_ana_test_en         = 0; // Disable analog test path
            dft_dphy_ocdldo_res_dis = 1; // No Load resistor for HSTX LDO necessary
            dft_pll_clks_2_cl_en    = 0; // route back the divided clock and the reference clock via DL1 and CL
            dft_scan_mode           = 0;
            en_clk_dphy             = 1; // Enable high speed clock for serializer
            hstx_en_fast_trf        = 1; // 0 = slow rise/fall (1 Gbps), 1 = fast rise/fall (2 Gbps)
            sel_dr                  = 1; // Datarate = 2Gbps
            en_clk_byte             = 1; // Enabled byte clock (derived from DL1), used for syncing the PRBS
            en_bias                 = 1;
            dphy_pwrdn              = 0;
            dphy_reset_n            = 1;
            en_iso_vddphy           = 1; // 1 = Disable isolation of digital control signals
            en_ls_vddphy            = 1; // enable bias currents
            hs_ser_msb_first_en     = 0; // 0 = LSB first, 1 = MSB first

            termination_en          = 1; // Enable termination resistor
            waveform_analyzer_ideal_min_max = 0; // We want to be more conservative on the min/max level detection

            deser_res_n = 1;
            deser_en = 1;

            loopback_prbs_checker_en[0] = 0; // No check for clk lane
            loopback_prbs_checker_en[1] = 1;
            loopback_prbs_checker_en[2] = 1;
            loopback_prbs_checker_en[3] = 1;
            loopback_prbs_checker_en[4] = 1;

            // Enable PRBS for all lanes
            for (i = 0; i<5; i=i+1) begin
                mode[i] = MODE_HSTX_PRBS;
                delay[i] = -1; // bypass mode of delay line
            end
            mode[0] = MODE_010;

            en_1GHz_quad = 1;  // Enable 1 GHz clock

            hstx_prbs_fail = 1; // Reset fail state

            // Reset the waveform analyzer
            waveform_analyzer_en = 0;
            waveform_analyzer_en_pulse_start = $abstime+5n;
            hstx_prbs_started = $abstime+10n; // give it some time so that the clock can adjust

        end
    end
end
