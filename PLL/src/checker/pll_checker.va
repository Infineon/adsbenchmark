// Disclaimer:
// THIS FILE IS PROVIDED AS IS AND WITH:
// (A) NO WARRANTY OF ANY KIND, express, implied or statutory, including any implied warranties of merchantability, fitness for a particular purpose and noninfringement, which  Infineon disclaims to the maximum extent permitted by applicable law; and
// (B) NO INDEMNIFICATION FOR INFRINGEMENT OF INTELLECTUAL PROPERTY RIGHTS.
// (C) LIMITATION OF LIABILITY: IN NO EVENT SHALL INFINEON BE LIABLE FOR ANY DIRECT, INDIRECT, SPECIAL, INCIDENTAL, OR CONSEQUENTIAL DAMAGES (INCLUDING LOST PROFITS OR SAVINGS) WHATSOEVER, WHETHER BASED ON CONTRACT, TORT OR ANY OTHER LEGAL THEORY, EVEN IF ADVISED OF THE POSSIBILITY OF SUCH DAMAGES.
// © 2020 Infineon Technologies AG. All rights reserved.

// Note:
// The CMOS transistor models used, were freely available models downloaded from: http://ptm.asu.edu.
// The bipolar transistor models are from: The Development of Bipolar Log-Domain Filters in a Standard CMOS Process, G. D. Duerden, G. W. Roberts, M. J. Deen, 2001

// Release:
// 	version 3.0

`include "constants.vams"
`include "disciplines.vams"

module pll_stim(adc_clk, ldo_clk, lock, sys_clk, ibias5u, adcdiv0, adcdiv1, adcdiv2, adcdiv3, adcdiv4, adcdiv5, adcdiv6, disable_e , fref, ldodiv0, ldodiv1, ldodiv2, ldodiv3, ldodiv4, ldodiv5, ldodiv6, sysdiv0, sysdiv1, sysdiv2, sysdiv3, sysdiv4, gnd, divtest, fail, testnr, test_en_i);
input adc_clk;
electrical adc_clk;
input test_en_i;
electrical test_en_i;
input ldo_clk;
electrical ldo_clk;
input lock;
electrical lock;
input sys_clk;
electrical sys_clk;
inout ibias5u;
electrical ibias5u;
output adcdiv0;
electrical adcdiv0;
output adcdiv1;
electrical adcdiv1;
output adcdiv2;
electrical adcdiv2;
output adcdiv3;
electrical adcdiv3;
output adcdiv4;
electrical adcdiv4;
output adcdiv5;
electrical adcdiv5;
output adcdiv6;
electrical adcdiv6;
output disable_e ;
electrical disable_e ;
output fref;
electrical fref;
output ldodiv0;
electrical ldodiv0;
output ldodiv1;
electrical ldodiv1;
output ldodiv2;
electrical ldodiv2;
output ldodiv3;
electrical ldodiv3;
output ldodiv4;
electrical ldodiv4;
output ldodiv5;
electrical ldodiv5;
output ldodiv6;
electrical ldodiv6;
output sysdiv0;
electrical sysdiv0;
output sysdiv1;
electrical sysdiv1;
output sysdiv2;
electrical sysdiv2;
output sysdiv3;
electrical sysdiv3;
output sysdiv4;
electrical sysdiv4;
input gnd;
electrical gnd;
output divtest;
electrical divtest;
output fail;
electrical fail;
output testnr;
electrical testnr;

integer sys_clk_i, adc_clk_i, ldo_clk_i, lock_i;
integer disable_i,fref_i;
integer enable_ref_clk = 0;
integer sysdiv_i, adcdiv_i , ldodiv_i, fail_i, testnr_i, divtest_i ;
parameter real    ibias_real = 5e-6;
parameter real    vhigh = 1.5;
parameter real    trf   = 1e-9;
parameter real    ref_freq = 7.373e6;
parameter real    freq_tolerance = 0.02;

real sysclk_freq = 0.0;
real adcclk_freq = 0.0;
real ldoclk_freq = 0.0;

real exp_sysclk_freq = 0.0;
real exp_adcclk_freq = 0.0;
real exp_ldoclk_freq = 0.0;

parameter integer period_averaging = 5;
real sysclk_rise[period_averaging:1]; // autom. initialized to 0.0 @ begin
real adcclk_rise[period_averaging:1]; // autom. initialized to 0.0 @ begin
real ldoclk_rise[period_averaging:1]; // autom. initialized to 0.0 @ begin

real next_ref_rise = 0.0;
real next_ref_fall = 0.0;

real clock_start_time    = -1;
real enable_time         = 1e-6;
real first_locking_time  = 21e-6;
real second_locking_time = 46e-6;
real third_locking_time  = 56e-6;
real disable_time        = 65e-6;
real check_outputs_low_time = -1.0; // set negative by default to avoid unintended activation
real exit_simulation_time   = -1.0;
real ref_time               = -1.0;

integer error_count = 0;
localparam integer test_disabled_at_start = 10;
localparam integer test_max_div_lock      = 20;
localparam integer test_min_div_lock      = 40;
localparam integer test_typ_div_lock      = 50;
localparam integer test_disabled_at_end   = 60;
localparam integer subtest_fail_at_lock   = 1;  // Purpose of subtest is to
                                                // indicate which signal failed
                                                // eg. value 32 means that
                                                // sysclk failed at second lock
localparam integer subtest_fail_at_sysclk = 2;
localparam integer subtest_fail_at_adcclk = 3;
localparam integer subtest_fail_at_ldoclk = 4;
localparam integer min_divisor = 4;
integer ongoing_testnr_i;

integer state = 0;
real next_state_time                 = -1.0;
real check_lock_time                 = -1.0;
real check_output_freq_time          = -1.0;
localparam integer INITIAL_STATE     = 0;
localparam integer MAX_DIVIDER_STATE = 1;
localparam integer MIN_DIVIDER_STATE = 2;
localparam integer TYP_DIVIDER_STATE = 3;
localparam integer END_STATE         = 10;
localparam real    locktime_min      = 10e-6;
localparam real    locktime_max      = 25e-6;
localparam real    lock_det_interval = 100e-9;
integer i, j, k;  // indices
real    lock_val=0.0; // Observe lock signal, needed to set freq. measurements
                      // to zero if lock is lost when measurement is done

/////////////////////////////////////////
// Pull reset high and start everthing
analog begin

    @(cross(V(test_en_i)-vhigh/2,1)) begin
        state            = INITIAL_STATE;
        clock_start_time = $abstime + 1p;
    end

    @(cross(V(test_en_i)-vhigh/2,-1)) begin
        state            = INITIAL_STATE;
        clock_start_time = $abstime - 1p; // in the past so it will
                                          // not be triggered
    end

end
/////////////////////////////////////////

analog begin // test sequencer

  @(initial_step) begin
      fref_i           =  0;
      disable_i        =  1;
      sysdiv_i         = 14;
      adcdiv_i         =  5;
      ldodiv_i         = 25;
      divtest_i        =  0;
      fail_i           =  0;
      testnr_i         =  0;
      ongoing_testnr_i =  0;
      state            =  0;

  end

@(timer( clock_start_time)) begin  // clock is started
    enable_ref_clk = 1;
    ongoing_testnr_i = test_disabled_at_start;
    ref_time = $abstime;
    check_outputs_low_time = enable_time - 10e-9;
    next_state_time = enable_time;
    state = INITIAL_STATE;
end

@(timer( next_state_time)) begin
    ref_time = $abstime;

if (state == INITIAL_STATE ) begin
      disable_i = 0;  //Enable the pll
      sysdiv_i =  31; //All dividers set to ffff
      adcdiv_i =  127;
      ldodiv_i =  127;
      divtest_i = 1;
      state = MAX_DIVIDER_STATE;
      ongoing_testnr_i = test_max_div_lock;
      check_lock_time = $abstime + locktime_min;
      next_state_time = $abstime + locktime_max;
end else if (state == MAX_DIVIDER_STATE ) begin
      disable_i = 0;  //Enable the pll
      sysdiv_i  = 0;  //All dividers set to 0 but min division seems to be 4
      adcdiv_i  = 0;
      ldodiv_i  = 0;
      divtest_i = 0;
      state     = MIN_DIVIDER_STATE;
      ongoing_testnr_i = test_min_div_lock;
      check_lock_time = $abstime + locktime_min;
      next_state_time = $abstime + locktime_max;
end else if  (state == MIN_DIVIDER_STATE ) begin
      disable_i = 0;  //enable the pll
      sysdiv_i = 14;
      adcdiv_i =  5;
      ldodiv_i = 25;
      divtest_i = 0;
      state     = TYP_DIVIDER_STATE;
      ongoing_testnr_i = test_typ_div_lock;
      check_lock_time = $abstime + locktime_min;
      next_state_time = $abstime + locktime_max;
end else if  (state == TYP_DIVIDER_STATE ) begin
      disable_i = 1;  //disable the pll
      state     = END_STATE;
      ref_time  = $abstime + 10e-9;
      next_state_time = $abstime + 1e-6;
      check_outputs_low_time = next_state_time - 10e-9;
end else if  (state == END_STATE ) begin
      exit_simulation_time =  $abstime + 1.5e-6;
end

end

@(timer( check_lock_time)) begin   //  check that frequencies are correct

   if( V(lock) > vhigh/2  || $abstime > next_state_time - lock_det_interval) begin
      if( V(lock) > vhigh/2) begin
         $strobe( " Lock detected high  @  %0.3e  !",  $abstime);
      end else  begin
         testnr_i = ongoing_testnr_i + subtest_fail_at_lock;
         $strobe( " ERROR testnumber: %f @  %0.3e : lock signal not high !", testnr_i , $abstime);
         fail_i   = 1;
      end

      if (divtest_i==0 && ldodiv_i > 10) begin
           check_output_freq_time = $abstime +2.5e-6;  // enough time for 410khz clock
      end else begin
           //check_output_freq_time = $abstime +1.1e-6; // enough time for 920khz clock
           check_output_freq_time = $abstime +2.5e-6; // enough time for 920khz clock

      end
      //next_state_time = $abstime + 3.0e-6;            // moved far enough (will be set again on check_output_freq_time)
      next_state_time = $abstime + 5.0e-6;            // moved far enough (will be set again on check_output_freq_time)

   end  else begin  // continue here
      $strobe( " Waiting for Lock signal to raise  @  %0.3e  !",  $abstime);
      check_lock_time =  $abstime + lock_det_interval;
   end

end

@(timer( check_output_freq_time)) begin   //  check that frequencies are correct

   $strobe( " CHECK @  %0.3e : checking that output clocks has expected frequency !", $abstime);

   $strobe(" sys_clk frequency:  %e ", sysclk_freq);
   if (sysdiv_i > min_divisor) begin
      exp_sysclk_freq = ref_freq*sysdiv_i*2.0;
   end else begin
      exp_sysclk_freq = ref_freq*(sysdiv_i+min_divisor)*2.0;
   end

   if ( ( sysclk_freq > exp_sysclk_freq*(1+freq_tolerance)) || ( sysclk_freq < exp_sysclk_freq*(1-freq_tolerance)) ) begin
      testnr_i = ongoing_testnr_i + subtest_fail_at_sysclk;
      $strobe( " ERROR testnumber: %f @  %0.3e : sys_clk frequency %e  not in range of: %e +- %f %%", testnr_i , $abstime, sysclk_freq , exp_sysclk_freq , freq_tolerance*100);
      fail_i   = 1;
   end

   $strobe( " adc_clk frequency:  %e ", adcclk_freq);
   if (adcdiv_i > min_divisor) begin
      exp_adcclk_freq = exp_sysclk_freq/(adcdiv_i*2.0);
   end else begin
      exp_adcclk_freq = exp_sysclk_freq/((adcdiv_i+min_divisor)*2.0);
   end

   if (  adcclk_freq > exp_adcclk_freq*(1+freq_tolerance) ||  adcclk_freq < exp_adcclk_freq*(1-freq_tolerance))  begin
      testnr_i = ongoing_testnr_i + subtest_fail_at_adcclk;
      $strobe( " ERROR testnumber: %f @  %0.3e : adc_clk frequency %e  not in range of: %e +- %f %%", testnr_i , $abstime, adcclk_freq , exp_adcclk_freq , freq_tolerance*100);
      fail_i   = 1;
   end

   $strobe( " ldo_clk frequency:  %e ", ldoclk_freq);
   if (divtest_i ) begin
      if (ldodiv_i > min_divisor) begin
         exp_ldoclk_freq = exp_sysclk_freq/(ldodiv_i*2.0);
      end else begin
         exp_ldoclk_freq = exp_sysclk_freq/((ldodiv_i+min_divisor)*2.0);
      end

   end else begin
       if (ldodiv_i > min_divisor) begin
         exp_ldoclk_freq = exp_adcclk_freq/(ldodiv_i*2.0);
      end else begin
         exp_ldoclk_freq = exp_adcclk_freq/((ldodiv_i+min_divisor)*2.0);
      end

   end
   if ( ldoclk_freq > exp_ldoclk_freq*(1+freq_tolerance) ||  ldoclk_freq < exp_ldoclk_freq*(1-freq_tolerance) )  begin
      testnr_i = ongoing_testnr_i + subtest_fail_at_ldoclk;
      $strobe( "ERROR testnumber: %f @  %0.3e : ldo_clk frequency %e  not in range of: %e +- %f %%", testnr_i , $abstime, ldoclk_freq ,exp_ldoclk_freq , freq_tolerance*100);
      fail_i   = 1;
   end

   next_state_time = $abstime + 10e-9;  // change to the next state as soon as freq is measured

end

@(timer( check_outputs_low_time)) begin   //  check that all outputs are 0

   if( V(lock) > vhigh/2) begin
      testnr_i = ongoing_testnr_i + subtest_fail_at_lock;
      $strobe( " ERROR testnumber: %f @  %0.3e : lock isn't low !", testnr_i , $abstime);
      fail_i   = 1;
   end

   $strobe( " CHECK @  %0.3e : checking that output clocks hasn't starrted !", $abstime);
   if(sysclk_rise[1] > ref_time || V(sys_clk) > vhigh/2) begin
      testnr_i = ongoing_testnr_i + subtest_fail_at_sysclk;
      $strobe( "ERROR testnumber: %f @  %0.3e : sys_clk has starrted !", testnr_i , $abstime);
      fail_i   = 1;
   end
   if(adcclk_rise[1] > ref_time || V(adc_clk) > vhigh/2) begin
      testnr_i = ongoing_testnr_i + subtest_fail_at_adcclk;
      $strobe( " ERROR testnumber: %f @  %0.3e : adc_clk has starrted !", testnr_i , $abstime);
      fail_i   = 1;
   end
   if(ldoclk_rise[1] > ref_time || V(ldo_clk) > vhigh/2) begin
      testnr_i = ongoing_testnr_i + subtest_fail_at_ldoclk;
      $strobe( " ERROR testnumber: %f @  %0.3e : ldo_clk has starrted !", testnr_i , $abstime);
      fail_i   = 1;
   end

end

@(cross(fail_i-0.5, 1)) begin
   exit_simulation_time = $abstime + 1e-6;
end

@(timer( exit_simulation_time)) begin   //
         enable_ref_clk = 0;
         disable_i      = 1;
         // $finish;
end

end

analog begin  //reference clock generation

@(initial_step)      fref_i = 0;

@(cross(enable_ref_clk-0.5, 1)) begin
   fref_i = 1;
   next_ref_fall = $abstime + (1.0/ref_freq)*0.5;
end

@(timer( next_ref_rise)) begin
   fref_i = enable_ref_clk;
   next_ref_fall = ($abstime + (1.0/ref_freq)*0.5)*enable_ref_clk;
end

@(timer( next_ref_fall)) begin
   fref_i = 0;
   next_ref_rise = ($abstime + (1.0/ref_freq)*0.5)*enable_ref_clk;
end

end

analog begin  // Frequency measurement:
  // Observing the lock signal is needed to zero out measurements
  // if lock is unstable
  @(cross(V(lock)-vhigh/2,+1)) lock_val=1.0;
  @(cross(V(lock)-vhigh/2,-1)) lock_val=0.0;

  @(cross(V(sys_clk)-vhigh/2, 1)) begin  // triggering on next rising edge
     sysclk_freq = period_averaging*1.0/($abstime - sysclk_rise[period_averaging]);
    for ( i=period_averaging; i>0; i=i-1) begin
       sysclk_rise[i] = (i==1) ? $abstime*lock_val : sysclk_rise[i-1];
    end
  end

  @(cross(V(adc_clk)-vhigh/2, 1)) begin  // triggering on next rising edge
     adcclk_freq = period_averaging*1.0/($abstime - adcclk_rise[period_averaging]);
    for ( j=period_averaging; j>0; j=j-1) begin
       adcclk_rise[j] = (j==1) ? $abstime*lock_val : adcclk_rise[j-1];
    end
  end

  @(cross(V(ldo_clk)-vhigh/2, 1)) begin  // triggering on next rising edge
      // no averaging for ldo_clk as it is allready divided a lot
      ldoclk_freq = 1.0/($abstime - ldoclk_rise[1]);
    for ( k=period_averaging; k>0; k=k-1) begin
       ldoclk_rise[k] = (k==1) ? $abstime*lock_val : ldoclk_rise[k-1];
    end
  end

end

analog begin   // conversions to electrical signals:

   V(fail)          <+  transition( fail_i*vhigh,0,trf,trf);
   V(testnr)        <+  transition( testnr_i*fail_i    ,0,trf,trf);

   V(fref)          <+ transition( fref_i*vhigh ,0,trf,trf);
   V(disable_e)     <+ transition( disable_i*vhigh ,0,trf,trf);
   I(ibias5u,gnd)   <+ transition( (disable_i == 0 ? ibias_real:0.0)  ,0,trf*5,trf/5);

   V(divtest)      <+ transition( divtest_i*vhigh ,0,trf,trf);

   V(sysdiv0)   <+ transition((sysdiv_i      % 2)*vhigh,0,trf,trf);
   V(sysdiv1)   <+ transition(((sysdiv_i/2)  % 2)*vhigh,0,trf,trf);
   V(sysdiv2)   <+ transition(((sysdiv_i/4)  % 2)*vhigh,0,trf,trf);
   V(sysdiv3)   <+ transition(((sysdiv_i/8)  % 2)*vhigh,0,trf,trf);
   V(sysdiv4)   <+ transition(((sysdiv_i/16) % 2)*vhigh,0,trf,trf);

   V(ldodiv0)   <+ transition((ldodiv_i      % 2)*vhigh,0,trf,trf);
   V(ldodiv1)   <+ transition(((ldodiv_i/2)  % 2)*vhigh,0,trf,trf);
   V(ldodiv2)   <+ transition(((ldodiv_i/4)  % 2)*vhigh,0,trf,trf);
   V(ldodiv3)   <+ transition(((ldodiv_i/8)  % 2)*vhigh,0,trf,trf);
   V(ldodiv4)   <+ transition(((ldodiv_i/16) % 2)*vhigh,0,trf,trf);
   V(ldodiv5)   <+ transition(((ldodiv_i/32) % 2)*vhigh,0,trf,trf);
   V(ldodiv6)   <+ transition(((ldodiv_i/64) % 2)*vhigh,0,trf,trf);

   V(adcdiv0)   <+ transition((adcdiv_i      % 2)*vhigh,0,trf,trf);
   V(adcdiv1)   <+ transition(((adcdiv_i/2)  % 2)*vhigh,0,trf,trf);
   V(adcdiv2)   <+ transition(((adcdiv_i/4)  % 2)*vhigh,0,trf,trf);
   V(adcdiv3)   <+ transition(((adcdiv_i/8)  % 2)*vhigh,0,trf,trf);
   V(adcdiv4)   <+ transition(((adcdiv_i/16) % 2)*vhigh,0,trf,trf);
   V(adcdiv5)   <+ transition(((adcdiv_i/32) % 2)*vhigh,0,trf,trf);
   V(adcdiv6)   <+ transition(((adcdiv_i/64) % 2)*vhigh,0,trf,trf);

end
endmodule
