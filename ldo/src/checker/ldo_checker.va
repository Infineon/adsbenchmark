// VerilogA for measurement, ldo_chk, veriloga
// Disclaimer:
// THIS FILE IS PROVIDED AS IS AND WITH:
// (A)  NO WARRANTY OF ANY KIND, express, implied or statutory, including any implied warranties of merchantability, fitness for a particular purpose and noninfringement, which Infineon disclaims to the maximum extent permitted by applicable law; and
// (B)  NO INDEMNIFICATION FOR INFRINGEMENT OF INTELLECTUAL PROPERTY RIGHTS.
// LIMITATION OF LIABILITY:  IN NO EVENT SHALL INFINEON BE LIABLE FOR ANY DIRECT, INDIRECT, SPECIAL, INCIDENTAL, OR CONSEQUENTIAL DAMAGES (INCLUDING LOST PROFITS OR SAVINGS) WHATSOEVER, WHETHER BASED ON CONTRACT, TORT OR
// ANY OTHER LEGAL THEORY, EVEN IF ADVISED OF THE POSSIBILITY OF SUCH DAMAGES.
// © 2020 Infineon Technologies AG. All rights reserved
// Release:
//	version 2.0

`include "constants.vams"
`include "disciplines.vams"

module ldo_chk (sigin,overvoltage,undervoltage,fail,testnr);
  input  sigin, undervoltage, overvoltage;
  output testnr, fail;
  electrical sigin, undervoltage, overvoltage;
  electrical fail, testnr;

  real failed, val1, val2, testflag;

  localparam real t_startup1   =49u,    t_startup2     =70u,
                  t_uv         =85u,    t_ov          =95u,
                  t_vdd_low1   =200u,   t_vdd_low2    =250u,
                  t_vdd_high1  =300u,   t_vdd_high2   =350u,
                  t_disable    =465u,
                  t_enable1    =530u,   t_enable2    =550u,
                  t_lo_vref1   =600u,   t_lo_vref2   =650u,
                  t_hi_vref1   =700u,   t_hi_vref2  =750u,
                  t_i_load_pos1=800u,   t_i_load_pos2=850u,
                  t_i_load_neg1=900u,   t_i_load_neg2=950u;

  localparam real vtol=5m;
  localparam real hilim=1.5+vtol, lolim=1.5-vtol;    //limits for ldo voltage
  localparam real hilim_lo_vref=1.438+vtol;
  localparam real lolim_lo_vref=1.438-vtol;    //limits for ldo voltage
  localparam real hilim_hi_vref=1.565+vtol;
  localparam real lolim_hi_vref=1.565-vtol;    //limits for ldo voltage
  localparam real maxdiff=7m;                //allowed difference between measurements
  localparam real maxidle=10m;               //max LDO voltage when disabled
  localparam real testidle      =7;            //"testnr" when idle voltage fails
  localparam real testlim       =8;            //"testnr" when voltage fails the limits
  localparam real testsettling  =9;            //"testnr" for settling fail
  localparam real testVDDa_ov_uv=10;            //"testnr" for LDO supply under/over voltage
  analog begin
    @(initial_step) begin
      failed = 0;
    end
    //********************* Statup *****************************
    //check voltage is in the limits
    @(timer(t_startup1)) begin
      val1 = V(sigin);
      $display("Time: %e\t\tVldo = %e", t_startup1, val1);
      if (val1 < lolim || val1 > hilim) begin
        failed=1;
        testflag=testlim;
		$display("Test @t_startup1=%e failed", t_startup1);
      end
    end
    // check for oscillation
    @(timer(t_startup2)) begin
      val2 = V(sigin);
      if (abs(val1-val2) > maxdiff) begin
        failed=1;
        testflag=testsettling;
		$display("Test @t_startup2=%e failed", t_startup2);
      end
      $display("Time: %e\t\tVdiff = %e", t_startup2, abs(val1-val2));
    end
    // ******************* VDDa +- 300mV *************************
	// ldo is disabled in case of supply undervoltage
    @(timer(t_uv)) begin
      val1 = V(sigin);
      $display("Time: %e\t\tIdle Vldo = %e", t_uv, val1);
      if (val1 > maxidle) begin
        failed=1;
        testflag=testidle;
        $display("Test @t_uv=%e failed", t_uv);
      end
      if (V(undervoltage) < 0.5) begin
        failed=1;
        testflag=testVDDa_ov_uv;
        $display("Test undervoltage failed");
      end
    end
	// ldo is disabled in case of supply overvoltage
    @(timer(t_ov)) begin
      val1 = V(sigin);
      $display("Time: %e\t\tIdle Vldo = %e", t_ov, val1);
      if (val1 > maxidle) begin
        failed=1;
        testflag=testidle;
        $display("Test @t_ov=%e failed", t_ov);
      end
      if (V(overvoltage) < 0.5) begin
        failed=1;
        testflag=testVDDa_ov_uv;
        $display("Test overvoltage failed");
      end
    end

    // ******************* VDDa +- 200mV *************************
    // check voltage is in the limits
    @(timer(t_vdd_low1)) begin
      val1 = V(sigin);
      $display("Time: %e\t\tVldo = %e", t_vdd_low1, val1);
      if (val1 < lolim || val1 > hilim) begin
        failed=1;
        testflag=testlim;
        $display("Test @t_vdd_low1=%e failed", t_vdd_low1);
      end
    end
    // check for  oscillation
    @(timer(t_vdd_low2)) begin
      val2 = V(sigin);
      if (abs(val1-val2) > maxdiff) begin
        failed=1;
        testflag=testsettling;
        $display("Test @t_vdd_low1=%e failed", t_vdd_low1);
      end
      $display("Time: %e\t\tVdiff = %e", t_vdd_low2, abs(val1-val2));
    end
    // check voltage is in the limits
    @(timer(t_vdd_high1)) begin
      val1 = V(sigin);
      $display("Time: %e\t\tVldo = %e", t_vdd_high1, val1);
      if (val1 < lolim || val1 > hilim) begin
        failed=1;
        testflag=testlim;
        $display("Test @t_vdd_high1=%e failed", t_vdd_high1);
      end
    end
    // check for  oscillation
    @(timer(t_vdd_high2)) begin
      val2 = V(sigin);
      if (abs(val1-val2) > maxdiff) begin
        failed=1;
        testflag=testsettling;
       $display("Test @t_vdd_high2=%e failed", t_vdd_high2);
      end
      $display("Time: %e\t\tVdiff = %e", t_vdd_high2, abs(val1-val2));
    end

    // *******************diable ldo *************************
    @(timer(t_disable)) begin
      val1 = V(sigin);
      $display("Time: %e\t\tIdle Vldo = %e", t_disable, val1);
      if (val1 > maxidle) begin
        failed=1;
        testflag=testidle;
		$display("Test @t_disable=%e failed", t_disable);
      end
    end

    // ******************* Enable ldo *************************
    // check voltage is in the limits
    @(timer(t_enable1)) begin
      val1 = V(sigin);
      $display("Time: %e\t\tVldo = %e", t_enable1, val1);
      if (val1 < lolim || val1 > hilim) begin
        failed=1;
        testflag=testlim;
		$display("Test @t_enable1=%e failed", t_enable1);
      end
    end
    // check for  oscillation
    @(timer(t_enable2)) begin
      val2 = V(sigin);
      if (abs(val1-val2) > maxdiff) begin
        failed=1;
        testflag=testsettling;
		$display("Test @t_enable2=%e failed", t_enable2);
      end
      $display("Time: %e\t\tVdiff = %e", t_enable2, abs(val1-val2));
    end
    // ******************* Vref +- 50mV *************************
    // check voltage is in the limits
    @(timer(t_lo_vref1)) begin
      val1 = V(sigin);
      $display("Time: %e\t\tVldo = %e", t_lo_vref1, val1);
      if (val1 < lolim_lo_vref || val1 > hilim_lo_vref) begin
        failed=1;
        testflag=testlim;
		$display("Test @t_lo_vref1=%e failed", t_lo_vref1);
      end
    end
    // check for  oscillation
    @(timer(t_lo_vref2)) begin
      val2 = V(sigin);
      if (abs(val1-val2) > maxdiff) begin
        failed=1;
        testflag=testsettling;
		$display("Test @t_lo_vref2=%e failed", t_lo_vref2);
      end
      $display("Time: %e\t\tVdiff = %e", t_lo_vref2, abs(val1-val2));
    end

    // check voltage is in the limits
    @(timer(t_hi_vref1)) begin
      val1 = V(sigin);
      $display("Time: %e\t\tVldo = %e", t_hi_vref1, val1);
      if (val1 < lolim_hi_vref || val1 > hilim_hi_vref) begin
        failed=1;
        testflag=testlim;
		$display("Test @t_hi_vref1=%e failed", t_hi_vref1);
      end
    end
    // check for  oscillation
    @(timer(t_hi_vref2)) begin
      val2 = V(sigin);
      if (abs(val1-val2) > maxdiff) begin
        failed=1;
        testflag=testsettling;
		$display("Test @t_hi_vref2=%e failed", t_hi_vref2);
      end
      $display("Time: %e\t\tVdiff = %e", t_hi_vref2, abs(val1-val2));
    end
	// *******************Iload = +/-5mA *************************
    // check voltage is in the limits
    @(timer(t_i_load_pos1)) begin
      val1 = V(sigin);
      $display("Time: %e\t\tVldo = %e", t_i_load_pos1, val1);
      if (val1 < lolim || val1 > hilim) begin
        failed=1;
        testflag=testlim;
		$display("Test @t_i_load_pos1=%e failed", t_i_load_pos1);
      end
    end
    // check for  oscillation
    @(timer(t_i_load_pos2)) begin
      val2 = V(sigin);
      if (abs(val1-val2) > maxdiff) begin
        failed=1;
        testflag=testsettling;
		$display("Test @t_i_load_pos2=%e failed", t_i_load_pos2);
      end
      $display("Time: %e\t\tVdiff = %e", t_i_load_pos2, abs(val1-val2));
    end

    // check voltage is in the limits
    @(timer(t_i_load_neg1)) begin
      val1 = V(sigin);
      $display("Time: %e\t\tVldo = %e", t_i_load_neg1, val1);
      if (val1 < lolim || val1 > hilim) begin
        failed=1;
        testflag=testlim;
      end
    end
    // check for  oscillation
    @(timer(t_i_load_neg2)) begin
      val2 = V(sigin);
      if (abs(val1-val2) > maxdiff) begin
        failed=1;
        testflag=testsettling;
      end
      $display("Time: %e\t\tVdiff = %e", t_i_load_neg2, abs(val1-val2));
    end

    // setup outputs
		V(fail) <+ transition(failed, 0, 1n, 1n);
		V(testnr) <+ transition(testflag,0,1n,1n);
  end
endmodule
