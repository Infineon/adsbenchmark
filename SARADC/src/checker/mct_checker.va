// Disclaimer:
// THIS FILE IS PROVIDED AS IS AND WITH:
// (A) NO WARRANTY OF ANY KIND, express, implied or statutory, including any implied warranties of merchantability, fitness for a particular purpose and noninfringement, which  Infineon disclaims to the maximum extent permitted by applicable law; and
// (B) NO INDEMNIFICATION FOR INFRINGEMENT OF INTELLECTUAL PROPERTY RIGHTS.
// (C) LIMITATION OF LIABILITY: IN NO EVENT SHALL INFINEON BE LIABLE FOR ANY DIRECT, INDIRECT, SPECIAL, INCIDENTAL, OR CONSEQUENTIAL DAMAGES (INCLUDING LOST PROFITS OR SAVINGS) WHATSOEVER, WHETHER BASED ON CONTRACT, TORT OR ANY OTHER LEGAL THEORY, EVEN IF ADVISED OF THE POSSIBILITY OF SUCH DAMAGES.
// © 2020 Infineon Technologies AG. All rights reserved.

// Note:
// The CMOS transistor models used, were freely available models downloaded from: http://ptm.asu.edu.
// The bipolar transistor models are from: The Development of Bipolar Log-Domain Filters in a Standard CMOS Process, G. D. Duerden, G. W. Roberts, M. J. Deen, 2001

// Release:
// version 1.0

// VerilogA for saradc_11bit_testbench - MCT, stimuli, veriloga

`include "constants.vams"
`include "disciplines.vams"

module stim_and_check_mct (clk_o,
				res_n_o,
				mod_ready_i,
				v_lv_0_o,
				v_lv_1_o,
				v_lv_2_o,
				chnr_o[4:0],
				start_adc_o,
				vrefp_i,
                		result_i[11:1],
               			 eoc_i,
               			dnl_max_o,
               			inl_max_o,
               			test_pass_o,
               			testnr,
               			fail,
               			test_en_i
				) ;

////////////////////////////////////
// Port definitions

input  mod_ready_i,
       eoc_i,
       vrefp_i,
       test_en_i;
input     [11:1]     result_i;

output  clk_o,
	    res_n_o,
		v_lv_0_o,
		v_lv_1_o,
		v_lv_2_o,
		start_adc_o,
       dnl_max_o,
       inl_max_o,
       test_pass_o,
       testnr,
       fail;
output [4:0] chnr_o;

electrical clk_o,
			res_n_o,
			mod_ready_i,
			v_lv_0_o,
			v_lv_1_o,
			v_lv_2_o,
			start_adc_o,
			vrefp_i,
       	    dnl_max_o,
      	    inl_max_o,
       	    test_pass_o,
            testnr,
       	    fail;
electrical [4:0] chnr_o;
electrical  [11:1] result_i;
electrical  eoc_i;
electrical  test_en_i;

integer clk;
integer res_n;
integer chnr[4:0];
integer start_adc;
real vrefp_real = 1.2;
////////////////////////////////////

////////////////////////////////////
// Parameter definitions
parameter real fclk = 28e6;
parameter real vhigh = 1.5;
parameter real vlow = 0;
parameter real trf = 30e-12;
parameter real clk_per_sample = 26;

// Limits:
parameter real min_dnl_spec = -0.9;
parameter real max_dnl_spec = 2.0;
parameter real max_inl_spec = 3.0;
parameter integer exit_on_inl_dnl_error = 0;  // change to 1 in order to exit in case DNL /INL is over the spec limit

////////////////////////////////////
// Parameters for Major Carry Test (MCT):

parameter real    epsilon_real   = 1.0/8.0;  // accuracy of searched threshold
parameter real    first_iter_width = 32.0;     // Defines the max distance from Vlow to Vmid  in lsb steps

parameter real  delay_between_samples = 1e-6;     // time used to wait for voltage ramp between 2 iterations
parameter real  delay_between_ranges = 1e-6;     // time used to wait for voltage ramp when range is changed

// range codes appended by high and low limits to calculate gain first
//localparam integer number_of_ranges = number_of_ranges_param + 2;
//localparam integer range_start_codes [1:number_of_ranges]  = { 2047, 1, {range_start_codes_param} };  // thresholds 2047 and 1 added to measure the average step size
//localparam integer range_stop_codes [1:number_of_ranges]   = { 2047, 1, {range_stop_codes_param}  };  //  over conversion range needed for DNL INL calculation

localparam real  delay_short = 10e-9;
localparam real    adc_ideal_step = 1.2/2048;
// constants for the statemachine (do not change the values during process):
localparam integer RESET_STATE = 0;
localparam integer START_STATE = 1;
localparam integer SET_VMID_STATE = 2;
localparam integer CONVERT_STATE = 3;
localparam integer NEXT_BIT_STATE= 4;
localparam integer STOP_STATE= 5;
localparam integer EXIT_STATE= 6;

// MCT variables
integer mct_state_int;
integer next_mct_state_int;
integer target_code_int;
real    test_voltage_real;
real    test_voltage_ramp_time_real;
real    next_state_time;
integer result_code_int;
real    dnl_real     = 0.0;
real    dnl_max_real = 0.0;
real    dnl_min_real = 0.0;
real    inl_real     = 0.0;
real    inl_max_real = 0.0;
real    prev_threshold_real = 0.0;
integer prev_code_int      = 0;
real    threshold_1_real    = 0.0;
real    threshold_2047_real = 0.0;
real    adc_step = 0.0;
real    adc_average_step;  // measured step
real    adc_offset;        // calculated code 0 threshold
real    vlow_real = 0.0;
real    vmid_real = 0.0;
real    vhigh_real = 0.0;
real    deltav_real = 0.0;
integer bit_numb;
real    vmct_real [10:0];
integer bit_seen_high;
integer bit_seen_low;
real    calculated_thresholds [0:2047];
real    dnl_result[1:2047];
real    inl_result[0:2047];
integer bit_val;

// file output :
integer  all_conversions_file;
integer  threshold_result_file;

////////////////////////////////////

////////////////////////////////////
// Tmp variables
integer i;
real next_clk_edge;
integer clock_enable;
real vthreshold = (vlow+vhigh)/2;

real sampleTime = clk_per_sample/fclk;

real nextSample = 100; // High value
real startadc_pull_low = 100; // High value
real ready_for_next_start;
integer test_pass = 0;
integer test_fail = 0;
integer testnr_i = 0;
real jump_steps_real = 0.0;
integer first_code_of_range = 0;
integer idx;

localparam test_threshold_not_in_range = 1;
localparam test_dnl_error              = 2;
localparam test_inl_error              = 3;

////////////////////////////////////

/////////////////////////////////////////
//Start everthing
analog begin

    @(cross(V(test_en_i)-vthreshold,1)) begin
        next_state_time = $abstime + 1p;
        next_mct_state_int = RESET_STATE;
        clock_enable = 1;
        next_clk_edge = $abstime + 0.5/fclk;
        $strobe(" Starting with MCT");
    end

    @(cross(V(test_en_i)-vthreshold,-1)) begin
        next_state_time = $abstime - 1p; // Time is in the past so it won't be triggered
        res_n=0;
        mct_state_int = RESET_STATE;
        next_mct_state_int = RESET_STATE;
        $strobe(" Stopping with MCT");
    end
end
/////////////////////////////////////////

analog begin

@(initial_step) begin
 // next_mct_state_int = RESET_STATE;
  clock_enable = 0;
  next_state_time = 1e6;
  all_conversions_file = $fopen("all_conversions.txt");
  threshold_result_file  = $fopen("threshold_results.txt");
  res_n=0;
  test_pass = 0;
  test_fail = 0;
  test_voltage_real = 0.0;
  test_voltage_ramp_time_real = delay_between_ranges;
  adc_step = adc_ideal_step;                  //start with ideal value
  target_code_int = 0;
  bit_seen_high = 0;
  bit_seen_low  = 0;

// for postprocessing testing only:
 /*   $strobe("POST PROCESSING ONLY WITH VALUES:");

vmct_real[10]	=	5.99688700E-01;
vmct_real[9]	=	3.00036600E-01;
vmct_real[8]	=	1.50183100E-01;
vmct_real[7]	=	7.53479000E-02;
vmct_real[6]	=	3.78479000E-02;
vmct_real[5]	=	1.90795900E-02;
vmct_real[4]	=	9.69843900E-03;
vmct_real[3]	=	4.98222400E-03;
vmct_real[2]	=	2.61371600E-03;
vmct_real[1]	=	1.42326100E-03;
vmct_real[0]	=	8.28E-04;

  bit_numb     = 0;
  bit_seen_low = 1;
  bit_seen_high= 1;
  vmid_real    = 8.816231e-04;
  next_mct_state_int = NEXT_BIT_STATE;  // uncomment this for getting directly to postprocessing
*/

end
end

analog begin
@(timer(next_state_time))  begin
  mct_state_int = next_mct_state_int;

  if ( mct_state_int == RESET_STATE) begin
    $strobe("mct_state @ RESET_STATE");
    res_n=1;
    next_mct_state_int = START_STATE;
    next_state_time = $abstime + delay_short;
    bit_numb = 10;
    $fstrobe(all_conversions_file, " This file contains all conversion results performed during testing in a format:");
    $fstrobe(all_conversions_file, " realtime , test_voltage, result_code");
    $fstrobe(threshold_result_file," This file contains flip thresholds for each Major Carry flip points:");

  //  next_mct_state_int = STOP_STATE;  // uncomment this for getting directly to postprocessing
  end

     ////////////////////////////////////////////////////////////////////////////////////////////////////////////////////////////////////////////////
     // START_STATE: sets the voltage levels ready for the first iteration
     //

    if ( mct_state_int == START_STATE ) begin
      $strobe("mct_state @ START_STATE");

      target_code_int    = 2**(bit_numb);
      if (2**(bit_numb) < first_iter_width) begin
         vlow_real  = 0.0;
         vmid_real  = adc_step*target_code_int;
         vhigh_real = vhigh_real;
      end else begin  // speeding up the search assuming that threshold is  never more than 32 steps away
         vlow_real  = adc_step*(target_code_int - first_iter_width);
         vmid_real  = adc_step*target_code_int;
         vhigh_real = adc_step*(target_code_int + first_iter_width);
      end

      deltav_real = vhigh_real - vlow_real;
      bit_seen_high = 0;
      bit_seen_low  = 0;

      test_voltage_ramp_time_real = delay_between_ranges;
      next_state_time =  $abstime + delay_between_ranges;
      next_mct_state_int = SET_VMID_STATE;

    end

     ////////////////////////////////////////////////////////////////////////////////////////////////////////////////////////////////////////////////
     // SET_VMID_STATE: sets the next vmid level

     if ( mct_state_int == SET_VMID_STATE ) begin
      $strobe("mct_state @ SET_VMID_STATE");
      test_voltage_real  = vmid_real;
      test_voltage_ramp_time_real = delay_between_samples;

       $strobe( " target_code: %d     ", target_code_int);
       $strobe( " vlow       : %0.3e  ", vlow_real);
       $strobe( " vmid       : %0.3e  ", vmid_real);
       $strobe( " vhigh      : %0.3e  ", vhigh_real);
       $strobe( " deltav     : %0.3e  ", deltav_real);

      next_mct_state_int = CONVERT_STATE;
      next_state_time =  $abstime + delay_between_samples;
    end

     ////////////////////////////////////////////////////////////////////////////////////////////////////////////////////////////////////////////////
     // NEXT_BIT_STATE: Changes the range to the next or starts the exit if last range

   if ( mct_state_int == NEXT_BIT_STATE ) begin
      $strobe("mct_state @ NEXT_BIT_STATE");
      vmct_real[bit_numb] = vmid_real;
      $fstrobe(threshold_result_file, " Bit %d flip voltage found from threshold  %0.6e  ", bit_numb , vmid_real);
      $strobe( " Bit %d flip voltage found from threshold  %0.6e  ", bit_numb , vmid_real);

      if (bit_numb > 0 && bit_seen_low == 1 && bit_seen_high== 1) begin
        next_mct_state_int = START_STATE;
        next_state_time = $abstime  + delay_short;
        bit_numb  = bit_numb -1;

      end else begin
         if (bit_seen_low == 0 || bit_seen_high== 0) begin
           $fstrobe(threshold_result_file, " ERROR @  %0.3e : Bit number %d did not got both values during threshold search at vhigh %0.3e !", $abstime, bit_numb, vhigh_real);
           $strobe( " ERROR @  %0.3e : Bit number %d did not got both values during threshold search at vhigh %0.3e !", $abstime, bit_numb, vhigh_real);
           test_pass = 0;
           test_fail = 1;
           testnr_i  = test_threshold_not_in_range;
           next_mct_state_int = EXIT_STATE;
           next_state_time = $abstime  + 1e-6; // to force fail to stay high for 1 us
         end else begin
           next_mct_state_int = STOP_STATE;
           next_state_time = $abstime  + delay_short;
         end

      end

    end

     ////////////////////////////////////////////////////////////////////////////////////////////////////////////////////////////////////////////////
     // STOP_STATE: reports the results to the result file and to the log file

    if ( mct_state_int == STOP_STATE ) begin
       $strobe("mct_state @ STOP_STATE");

       $strobe("================================================== ");
       $strobe("                 DNL INL RESULTS:                  ");
       $strobe("                                                   ");
       $fstrobe(threshold_result_file,"================================================== ");
       $fstrobe(threshold_result_file,"                 DNL INL RESULTS:                  ");
       $fstrobe(threshold_result_file,"                                                   ");

       // adc average_step is calcullated on average from bit 10 flip to bit 0 flip to get rid of offset
       adc_average_step = (vmct_real[10] - vmct_real[0])/(2**10-2**0);
       $strobe(" adc average step calculated: %0.6e ", adc_average_step);

      for ( idx = 0; idx <11; idx=idx+1) begin
         adc_offset = adc_offset + vmct_real[idx] - adc_average_step*2**idx;
      end
         adc_offset = adc_offset/11.0; // average of all bit offsets
       $strobe(" adc ofset calculated: %0.6e ", adc_offset);

       $strobe(" Calculating DNL and INL based on these threshold results: ");

       for ( idx = 0; idx <11; idx=idx+1) begin
          $fstrobe(threshold_result_file," Threshold for bit %d ,  %0.6e ", idx, vmct_real[idx]);
       end

       inl_result[0] = 0.0;

        $strobe(" code, threshold, dnl, inl       ");
        $strobe(" code, threshold, dnl, inl       ");

       for ( idx = 1; idx <2**11; idx=idx+1) begin
              calculated_thresholds[idx] = 0.0;
          for ( bit_numb = 0; bit_numb <11; bit_numb=bit_numb+1) begin
              bit_val = (idx/(2**bit_numb)) % 2;
              calculated_thresholds[idx] =  calculated_thresholds[idx] + (vmct_real[bit_numb]-adc_offset)*bit_val;
          end
          if (idx > 0) begin
              dnl_result[idx] = (calculated_thresholds[idx] - calculated_thresholds[idx-1])/adc_average_step -1.0;

              if (dnl_result[idx] < -1.0)   dnl_result[idx] = -1.0;  // limited to -1

              inl_result[idx] =   inl_result[idx-1] + dnl_result[idx];

              if ( (dnl_result[idx]) > dnl_max_real) begin
                  dnl_max_real = dnl_result[idx];
              end

              if ( (dnl_result[idx]) < dnl_min_real) begin
                  dnl_min_real = dnl_result[idx];
              end

              if ( abs(inl_result[idx]) > inl_max_real) begin
                  inl_max_real = abs(inl_result[idx]);
              end
         $strobe(" %d, %0.6e, %0.3e , %0.3e", idx,calculated_thresholds[idx], dnl_result[idx],  inl_result[idx]       );
         $fstrobe(threshold_result_file," %d, %0.6e, %0.3e , %0.3e", idx,calculated_thresholds[idx], dnl_result[idx],  inl_result[idx]       );
         end

       end

       if (dnl_max_real > max_dnl_spec || dnl_min_real < min_dnl_spec) begin
          $strobe(" DNL test FAIL: result min: %0.3e  max: %0.3e corresponding limits %0.3e to %0.3e  ", dnl_min_real, dnl_max_real, min_dnl_spec, max_dnl_spec);
          $fstrobe(threshold_result_file," DNL test FAIL: result min: %0.3e  max: %0.3e corresponding limits %0.3e to %0.3e  ", dnl_min_real, dnl_max_real, min_dnl_spec, max_dnl_spec);
          testnr_i  = test_dnl_error;
       end else begin
          $strobe(" DNL test PASS: result %0.3e  limit %0.3e ", dnl_max_real, max_dnl_spec);
          $fstrobe(threshold_result_file," DNL test PASS: result %0.3e  limit %0.3e ", dnl_max_real, max_dnl_spec);
       end

       if (inl_max_real > max_inl_spec) begin
          $strobe(" INL test FAIL: result %0.3e  limit %0.3e ", inl_max_real, max_inl_spec);
          $fstrobe(threshold_result_file," INL test FAIL: result %0.3e  limit %0.3e ", inl_max_real, max_inl_spec);
          testnr_i  = test_inl_error;
       end else begin
          $strobe(" INL test PASS: result %0.3e  limit %0.3e ", inl_max_real, max_inl_spec);
          $fstrobe(threshold_result_file," INL test PASS: result %0.3e  limit %0.3e ", inl_max_real, max_inl_spec);
       end

       if (dnl_max_real > max_dnl_spec  || dnl_min_real < min_dnl_spec || inl_max_real > max_inl_spec ) begin
          test_pass = 0;
          test_fail = 1;
       end else begin
          test_pass = 1;
          test_fail = 0;
       end

      next_mct_state_int = EXIT_STATE;
      next_state_time = $abstime  + 1e-6;

    end

     ////////////////////////////////////////////////////////////////////////////////////////////////////////////////////////////////////////////////
     // EXIT_STATE: Exits the simulation after a delay to give time for pass/fail detection

    if ( mct_state_int == EXIT_STATE ) begin

       $strobe("                                                   ");
       $strobe("================================================== ");
       $fstrobe(threshold_result_file,"                                                   ");
       $fstrobe(threshold_result_file,"================================================== ");

       $fclose(all_conversions_file);
       $fclose(threshold_result_file);
       $finish_current_analysis;
    end
end
end

analog begin

@(timer( next_state_time)) begin
   mct_state_int = next_mct_state_int;
end
@(cross(V(eoc_i)-vthreshold, -1) ) begin

     ////////////////////////////////////////////////////////////////////////////////////////////////////////////////////////////////////////////////
     // CONVERT_STATE: Samples the conversion result on falling edge of eoc_i, calculates dnl & inl

    if ( mct_state_int ==  CONVERT_STATE ) begin

       $strobe("Conversion result @ %0.6e : %f %f %f . %f %f %f %f . %f %f %f %f", $abstime, V(result_i[11])/1.5, V(result_i[10])/1.5, V(result_i[9])/1.5, V(result_i[8])/1.5,
																				   V(result_i[7])/1.5, V(result_i[6])/1.5, V(result_i[5])/1.5, V(result_i[4])/1.5, V(result_i[3])/1.5,
																				   V(result_i[2])/1.5, V(result_i[1])/1.5);

        result_code_int = 0;
        result_code_int = (V(result_i[1])  > vthreshold) ? result_code_int + 2**(1-1): result_code_int ;
        result_code_int = (V(result_i[2])  > vthreshold) ? result_code_int + 2**(2-1): result_code_int ;
        result_code_int = (V(result_i[3])  > vthreshold) ? result_code_int + 2**(3-1): result_code_int ;
        result_code_int = (V(result_i[4])  > vthreshold) ? result_code_int + 2**(4-1): result_code_int ;
        result_code_int = (V(result_i[5])  > vthreshold) ? result_code_int + 2**(5-1): result_code_int ;
        result_code_int = (V(result_i[6])  > vthreshold) ? result_code_int + 2**(6-1): result_code_int ;
        result_code_int = (V(result_i[7])  > vthreshold) ? result_code_int + 2**(7-1): result_code_int ;
        result_code_int = (V(result_i[8])  > vthreshold) ? result_code_int + 2**(8-1): result_code_int ;
        result_code_int = (V(result_i[9])  > vthreshold) ? result_code_int + 2**(9-1): result_code_int ;
        result_code_int = (V(result_i[10]) > vthreshold) ? result_code_int + 2**(10-1): result_code_int ;
        result_code_int = (V(result_i[11]) > vthreshold) ? result_code_int + 2**(11-1): result_code_int ;

       $fstrobe(all_conversions_file, " %0.3e , %0.6e , %d", $abstime, test_voltage_real, result_code_int);
       $strobe("Conversion result @ %0.3e : %0.6e , %d", $abstime, test_voltage_real, result_code_int);  // same info to log file

       if (result_code_int < target_code_int) begin
         deltav_real = vhigh_real -vmid_real;
         vlow_real = vmid_real;
         vmid_real = (vhigh_real + vmid_real) *0.5 ;
         vhigh_real = vhigh_real;
         bit_seen_low = 1;
       end else begin
         deltav_real = vmid_real -vlow_real;
         vlow_real = vlow_real;
         vhigh_real = vmid_real;
         vmid_real = (vlow_real + vmid_real) *0.5 ;
         bit_seen_high = 1;
       end

      if ( deltav_real > adc_step*epsilon_real) begin
        next_mct_state_int = SET_VMID_STATE;
      end else begin
        next_mct_state_int = NEXT_BIT_STATE;
      end
      next_state_time = $abstime  + delay_short;

   end
end
end

////////////////////////////////////
// Do sampling
integer conversion_ongoing = 0;

analog begin

    @(timer(ready_for_next_start)) begin
		conversion_ongoing = 0;
    end

    @(cross(clk-0.5, 1)) begin  // triggering on next rising edge
        startadc_pull_low =  $abstime + 1/fclk;

        if ( mct_state_int ==  CONVERT_STATE && conversion_ongoing == 0 ) begin
	      start_adc = 1;
          conversion_ongoing = 1;
          ready_for_next_start = $abstime + 30/fclk;  // reserves time for the ongoing conversion
          startadc_pull_low =  $abstime + 1/fclk;

        end else begin
	      start_adc = 0;
          //ready_for_next_start = $abstime + 2/fclk;
        end

    end

    @(timer(startadc_pull_low)) begin
		start_adc = 0;
    end

end
////////////////////////////////////

////////////////////////////////////
// Clock
analog begin

    @(timer(next_clk_edge)) begin

        if (clock_enable == 1) begin
            clk = !clk;
        end else begin
            clk = 0;
        end
        next_clk_edge = next_clk_edge + 0.5/fclk;
    end

end
////////////////////////////////////

////////////////////////////////////
// Assignments to outputs
analog begin
  @(initial_step) begin
	clk = 0;
    next_clk_edge=-1p;
    chnr[0] = 1;
    chnr[1] = 1;
    chnr[2] = 0;
    chnr[3] = 1;
    chnr[4] = 0;
	start_adc = 0;
  end

   V(res_n_o)     <+ transition(vlow+res_n*(vhigh-vlow),0,trf,trf);
   V(chnr_o[0])   <+ transition(vlow+chnr[0]*(vhigh-vlow),0,trf,trf);
   V(chnr_o[1])   <+ transition(vlow+chnr[1]*(vhigh-vlow),0,trf,trf);
   V(chnr_o[2])   <+ transition(vlow+chnr[2]*(vhigh-vlow),0,trf,trf);
   V(chnr_o[3])   <+ transition(vlow+chnr[3]*(vhigh-vlow),0,trf,trf);
   V(chnr_o[4])   <+ transition(vlow+chnr[4]*(vhigh-vlow),0,trf,trf);
   V(start_adc_o) <+ transition(vlow+start_adc*(vhigh-vlow),0,trf,trf);
   V(clk_o)       <+ transition(vlow+clk*(vhigh-vlow),0,trf,trf);

   V(dnl_max_o)   <+ transition(dnl_max_real,0,trf,trf);
   V(inl_max_o)   <+ transition(inl_max_real,0,trf,trf);
   V(test_pass_o) <+ transition(vlow+test_pass*(vhigh-vlow),0,trf,trf);
   V(fail)        <+ transition(vlow+test_fail*(vhigh-vlow),0,trf,trf);
   V(testnr)      <+ transition(vlow+testnr_i*test_fail,0,trf,trf);

// same test signal given for all input signals
    V(v_lv_0_o)  <+ transition(test_voltage_real,0,test_voltage_ramp_time_real, test_voltage_ramp_time_real);
    V(v_lv_1_o)  <+ transition(test_voltage_real,0,test_voltage_ramp_time_real, test_voltage_ramp_time_real);
    V(v_lv_2_o)  <+ transition(test_voltage_real,0,test_voltage_ramp_time_real, test_voltage_ramp_time_real);

end
////////////////////////////////////

endmodule
