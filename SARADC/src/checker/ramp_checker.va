// Disclaimer:
// THIS FILE IS PROVIDED AS IS AND WITH:
// (A) NO WARRANTY OF ANY KIND, express, implied or statutory, including any implied warranties of merchantability, fitness for a particular purpose and noninfringement, which  Infineon disclaims to the maximum extent permitted by applicable law; and
// (B) NO INDEMNIFICATION FOR INFRINGEMENT OF INTELLECTUAL PROPERTY RIGHTS.
// (C) LIMITATION OF LIABILITY: IN NO EVENT SHALL INFINEON BE LIABLE FOR ANY DIRECT, INDIRECT, SPECIAL, INCIDENTAL, OR CONSEQUENTIAL DAMAGES (INCLUDING LOST PROFITS OR SAVINGS) WHATSOEVER, WHETHER BASED ON CONTRACT, TORT OR ANY OTHER LEGAL THEORY, EVEN IF ADVISED OF THE POSSIBILITY OF SUCH DAMAGES.
// © 2020 Infineon Technologies AG. All rights reserved.

// Note:
// The CMOS transistor models used, were freely available models downloaded from: http://ptm.asu.edu.
// The bipolar transistor models are from: The Development of Bipolar Log-Domain Filters in a Standard CMOS Process, G. D. Duerden, G. W. Roberts, M. J. Deen, 2001

// Release:
// version 1.0

// VerilogA for saradc_11bit_testbench - RAMP, veriloga

// VerilogA for  adc_dnl_11bit, veriloga
//
`include "constants.vams"
`include "disciplines.vams"

//--------------------
// This code calculates the dnl max and min and compares it to the spec
// It bases the calculation of the dnl on historgram
// The bins of the histogram are filled by a ramp provided to the ADC
// Input Signals:
// vd<10:0> : The digital 11 bit code coming out of the ADC to this block
// record   : a digital signal indicating the End Of Conversion
//			  This signal triggers this block to fill one of the bins
// venable	: This enables the whole block or disables it
//			: If it is high, the histogram bins
// Output Signals:
// bad_dnl  : testnr -> if the max/min dnl is outside the given specs in the parameters or a catastrophic fail occurred
//			  0 -> if the adc is within the specs

module dnl_inl11bit_chk( vd10, vd9, vd8, vd7, vd6, vd5, vd4, vd3, vd2, vd1, vd0,
				 record, venable, dnl_prev_approx_o, testid_o );
electrical vd10, vd9 ,vd8,vd7, vd6, vd5, vd4, vd3, vd2, vd1, vd0;
electrical record, venable, testid_o;
electrical dnl_prev_approx_o;

parameter integer debug    = 0; // If 1, then enable verbose output and write the dnl.dat in the netlist directory

/* **************************** */
/* Catastrophic Fault Detection */
parameter integer cata_N1    = 3;  // Comparing the code N1-1 codes before the current code n with the average
parameter integer cata_N2    = 5;  // Building the average with N2 codes (starting at n-N1 to n-N1-N2)
parameter real    cata_alpha = 0.5;// Percentage threshold for throwing an error (average should not deviate more than +- alpha percent from the average)
integer cata_A; // tmp variable
integer cata_B; // tmp variable
real cata_avg;  // tmp variable
/* **************************** */

parameter integer hits_per_code = 10;
parameter real vlogic_high=5.0;			  //Voltage level of logic 1
parameter real vlogic_low=0.0;			  //Voltage level of logic 0
parameter integer dnl_approx_steps = 2;  //Which code in the past do you want to use for the DNL approximation?

parameter real spec_min_dnl = -0.9;		  //min dnl should be <-0.9
parameter real spec_max_dnl =  0.9;		  //max dnl should be >+0.9
parameter real spec_min_inl = -3;		  //min inl should be <-3
parameter real spec_max_inl =  3;		  //max inl should be >+3

real testid = 0;                         //TestID Voltage
real testid_bad_dnl = 4;                 //4V if DNL test fails
real testid_bad_inl = 5;                 //5V if INL test fails
real testid_catastrophic_fail = 6;       //6V if catastrophic test fails
real testid_bad_dnl_and_inl = 11;        //11V if catastrophic test fails

`define NUM_OF_CODES 2048  //11 bits adc

integer file_operator;             // file operator
integer conv_num;	               // conversion number
integer i;	                       //counter for the for loops
real    vtrans;	                   //half of the diff bet. logic high and logic low voltages
integer measurement_active;
integer hist_ready;                // 1 --> finished histogram, start dnl calculations
integer code, code_tmp;
integer bin[0:`NUM_OF_CODES-1];    // holds number of code hits for each code
real    width [0:`NUM_OF_CODES-1]; // code width vector
real    dnl   [0:`NUM_OF_CODES-1]; // dnl vector
real    inl   [0:`NUM_OF_CODES-1]; // inl vector
integer total_hits;     // totals hits between codes 1 and 2046
integer total_hits_past; // total hits for the dnl approximation
real hits_mean;
real dnl_approx;
real    max_dnl;
integer max_dnl_code;
real    min_dnl;
integer min_dnl_code;
real    max_inl;
integer max_inl_code;
real    min_inl;
integer min_inl_code;
real avg;

analog begin
  @ ( initial_step ) begin
     conv_num = 0;
     vtrans = (vlogic_high-vlogic_low)/2;
     measurement_active=0;
     hist_ready = 0;
     total_hits = 0;
     min_dnl = 0;
     max_dnl = 0;
     dnl_approx = 0;
     min_inl = 0;
     max_inl = 0;
     total_hits_past = 0;
     for (i=0; i < `NUM_OF_CODES; i = i + 1) begin
        bin[i] = 0;
     end
     if (debug) begin
         file_operator = $fopen( "dnl.dat" );
     end
  end

  @ (cross(V(record)-vtrans, 1)) begin   //Positive edge of EoC
     if(V(venable)>(vlogic_high-vlogic_low)/2) begin
	    measurement_active= 1;
 	    //Increase the conversion number to
	    conv_num = conv_num + 1;

        // calculate the decimal value
	    // Sum(2^i*vdi) for i = 0 to 10 (11 bits)
        code_tmp = 0; // use tmp variable to calculate the decimal value
        code_tmp = code_tmp + (V(vd0) > vtrans)*1;
        code_tmp = code_tmp + (V(vd1) > vtrans)*2;
        code_tmp = code_tmp + (V(vd2) > vtrans)*4;
        code_tmp = code_tmp + (V(vd3) > vtrans)*8;
        code_tmp = code_tmp + (V(vd4) > vtrans)*16;
        code_tmp = code_tmp + (V(vd5) > vtrans)*32;
        code_tmp = code_tmp + (V(vd6) > vtrans)*64;
        code_tmp = code_tmp + (V(vd7) > vtrans)*128;
        code_tmp = code_tmp + (V(vd8) > vtrans)*256;
        code_tmp = code_tmp + (V(vd9) > vtrans)*512;
        code_tmp = code_tmp + (V(vd10) > vtrans)*1024;

		/* Catastrophic Faul Detection - START */
           if (code_tmp > 1+cata_N1+cata_N2) begin

				// Only perform check if a new code has been touched
				// It triggers if a code deviates too much from the previous average
				if(bin[code_tmp]==1) begin

					// Calculate average hits per code from before
					cata_A = code_tmp - cata_N1;
					cata_B = cata_A - cata_N2;
					cata_avg = 0;
					for (i=cata_B;i<=cata_A;i=i+1) begin
						cata_avg = cata_avg + bin[i];
					end
					cata_avg = cata_avg/cata_N2;

					if(cata_alpha*cata_avg <= bin[cata_A+1] &&
					   bin[cata_A+1]       <= (1+cata_alpha)*cata_avg) begin
						if(debug) begin
							$display("Code %d is okay", cata_A+1);
							for (i=cata_B;i<=code_tmp;i=i+1) begin
								$display("Hits of code %d: %d", i, bin[i]);
							end
						end
					end else begin
						if(debug) begin
							$display("Code %d is not okay", cata_A+1);
							for (i=cata_B;i<=code_tmp;i=i+1) begin
								$display("Hits of code %d: %d", i, bin[i]);
							end
							$finish_current_analysis;
						end
	  				    testid = testid_catastrophic_fail;
					end
				end
			end
		/* Catastrophic Faul Detection - END */

        /*
        DNL Approximation calculation:
        If code change, recalulate the complete histogram up to this new code. This makes sure, that the approximation
        gets more precise the longer the simulation runs.
        */
		if (code_tmp > code && code_tmp>dnl_approx_steps+2) begin
			// A new code has been registered -> update the DNL approximation
			total_hits_past = 0;
			for (i=1;i<code_tmp-dnl_approx_steps+1;i=i+1) begin
				total_hits_past = total_hits_past + bin[i]; // Redo the dnl approximation
			end
			// Calculate the DNL approximation
			avg = total_hits_past*1.0/(code_tmp-dnl_approx_steps);
			dnl_approx = bin[code_tmp-dnl_approx_steps]/avg - 1.0;
        end

		code = code_tmp; // update the real code

	    //Increase the bin of output code
	    bin[code] = bin[code] + 1;

     end else begin
         if (measurement_active) begin
            hist_ready=1;
	     end
     end//if venable
   end //cross vrecord

   // calculate  dnl
   if (hist_ready) begin
      hist_ready = 0;
      total_hits = 0;
      for (i=1; i < `NUM_OF_CODES-1; i = i + 1) begin
         total_hits = total_hits + bin[i];
      end
      if(total_hits>0) begin
         hits_mean = total_hits/(1.0*(`NUM_OF_CODES-2));

         inl[0]=0.0;
         if (debug) begin
            $fstrobe(file_operator,"code \t hits \t dnl \t inl");
         end

         for (i=1; i < `NUM_OF_CODES-1; i = i + 1) begin
            width[i] = bin[i]/hits_mean;
            dnl[i] = width[i] - 1.0;
            if (max_dnl < dnl[i]) begin
               max_dnl = dnl[i];
               max_dnl_code = i;
            end else if (min_dnl>dnl[i]) begin
               min_dnl = dnl[i];
               min_dnl_code = i;
            end
         inl[i]=inl[i-1]+dnl[i];
            if (max_inl < inl[i]) begin
               max_inl = inl[i];
               max_inl_code = i;
            end else if (min_inl>inl[i]) begin
               min_inl = inl[i];
               min_inl_code = i;
            end

            // Store dnls, inls to a file
            if (debug) begin
               $fstrobe(file_operator,"%d \t %d \t %f \t %f",i,bin[i],dnl[i],inl[i]);
            end
         end//for on codes

      if (debug) begin
         $fclose(file_operator);
         end

         if(max_dnl>spec_max_dnl || min_dnl<spec_min_dnl) begin
         testid = testid_bad_dnl;
         end

         if(max_inl>spec_max_inl || min_inl<spec_min_inl) begin
         if(testid == testid_bad_dnl) begin
            testid = testid_bad_dnl_and_inl; // DNL and INL is not okay!
         end else begin
            testid = testid_bad_inl;
         end
         end

         if(debug) begin
            $display("Total Hits: %d", total_hits);
            $display("Mean Hits: %f", hits_mean);
            $display("DNL min: %f", min_dnl);
            $display("DNL min code: %f", min_dnl_code);
            $display("DNL max: %f", max_dnl);
            $display("DNL max code: %f", max_dnl_code);
            $display("INL max: %f", max_inl);
            $display("INL max code: %f", max_inl_code);
            $display("INL min: %f", min_inl);
            $display("INL min code: %f", min_inl_code);
         $finish_current_analysis;
         end

      end else begin
      	$display("Total Hits = 0!");
        // throw error
		testid = testid_bad_dnl_and_inl;
      end
   end //if hist_ready

   /* This script can end the simulation if a catastrophic fail occurres. Just uncomment it.
   @ (cross(V(testid_o)-vtrans, 1)) begin
	    $finish_current_analysis;
   end
   */

   V(dnl_prev_approx_o) <+ transition(dnl_approx, 0, 1n, 1n);
   V(testid_o) <+ transition(testid,0,1n,1n);
   end
endmodule
